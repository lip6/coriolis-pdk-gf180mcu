.SUBCKT gf180mcu_fd_sc_mcu9t5v0__invz_2 EN I ZN VDD VSS
*.PININFO EN:I I:I ZN:O VDD:P VDD:P VSS:P VSS:G
*.EQN ZN=!I
M_XX27 VSS EN NEN VSS nmos_6p0 W=1.320000U L=0.600000U
M_XX44 NI_N NEN VSS VSS nmos_6p0 W=1.320000U L=0.600000U
M_XX36 NI_P EN NI_N VSS nmos_6p0 W=1.320000U L=0.600000U
M_XX43 VSS NI NI_N VSS nmos_6p0 W=1.320000U L=0.600000U
M_XX22 ZN NI_N VSS VSS nmos_6p0 W=1.320000U L=0.600000U
M_XX22_4 VSS NI_N ZN VSS nmos_6p0 W=1.320000U L=0.600000U
M_Mn_inv NI I VSS VSS nmos_6p0 W=1.320000U L=0.600000U
M_XX28 VDD EN NEN VDD pmos_6p0 W=1.800000U L=0.500000U
M_XX45 NI_P EN VDD VDD pmos_6p0 W=1.800000U L=0.500000U
M_XX39 NI_N NEN NI_P VDD pmos_6p0 W=1.800000U L=0.500000U
M_XX46 VDD NI NI_P VDD pmos_6p0 W=1.800000U L=0.500000U
M_XX21 ZN NI_P VDD VDD pmos_6p0 W=1.800000U L=0.500000U
M_XX21_5 VDD NI_P ZN VDD pmos_6p0 W=1.800000U L=0.500000U
M_Mp_inv NI I VDD VDD pmos_6p0 W=1.800000U L=0.500000U
.ENDS
