.SUBCKT gf180mcu_fd_sc_mcu9t5v0__aoi222_1 A1 A2 B1 B2 C1 C2 ZN VDD VSS
*.PININFO A1:I A2:I B1:I B2:I C1:I C2:I ZN:O VDD:P VDD:P VSS:P VSS:G
*.EQN ZN=!(((A1 * A2) + (B1 * B2)) + (C1 * C2))
M_i_5 net_2 C2 VSS VSS nmos_6p0 W=1.320000U L=0.600000U
M_i_4 ZN C1 net_2 VSS nmos_6p0 W=1.320000U L=0.600000U
M_i_2 net_1 B1 ZN VSS nmos_6p0 W=1.320000U L=0.600000U
M_i_3 VSS B2 net_1 VSS nmos_6p0 W=1.320000U L=0.600000U
M_i_1 net_0 A2 VSS VSS nmos_6p0 W=1.320000U L=0.600000U
M_i_0 ZN A1 net_0 VSS nmos_6p0 W=1.320000U L=0.600000U
M_i_11 net_4 C2 VDD VDD pmos_6p0 W=1.830000U L=0.500000U
M_i_10 VDD C1 net_4 VDD pmos_6p0 W=1.830000U L=0.500000U
M_i_8 net_4 B1 net_3 VDD pmos_6p0 W=1.830000U L=0.500000U
M_i_9 net_3 B2 net_4 VDD pmos_6p0 W=1.830000U L=0.500000U
M_i_7 ZN A2 net_3 VDD pmos_6p0 W=1.830000U L=0.500000U
M_i_6 net_3 A1 ZN VDD pmos_6p0 W=1.830000U L=0.500000U
.ENDS
