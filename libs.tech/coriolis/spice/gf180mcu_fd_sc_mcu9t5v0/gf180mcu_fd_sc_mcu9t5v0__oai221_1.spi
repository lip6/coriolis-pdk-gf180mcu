.SUBCKT gf180mcu_fd_sc_mcu9t5v0__oai221_1 A1 A2 B1 B2 C ZN VDD VSS
*.PININFO A1:I A2:I B1:I B2:I C:I ZN:O VDD:P VDD:P VSS:P VSS:G
*.EQN ZN=!(((A1 + A2) * (B1 + B2)) * C)
M_i_4 VSS B2 net_1 VSS nmos_6p0 W=1.320000U L=0.600000U
M_i_3 net_1 B1 VSS VSS nmos_6p0 W=1.320000U L=0.600000U
M_i_2 net_0 C net_1 VSS nmos_6p0 W=1.320000U L=0.600000U
M_i_1 ZN A2 net_0 VSS nmos_6p0 W=1.320000U L=0.600000U
M_i_0 net_0 A1 ZN VSS nmos_6p0 W=1.320000U L=0.600000U
M_i_9 net_3 B2 VDD VDD pmos_6p0 W=1.830000U L=0.500000U
M_i_8 ZN B1 net_3 VDD pmos_6p0 W=1.830000U L=0.500000U
M_i_7 VDD C ZN VDD pmos_6p0 W=1.460000U L=0.500000U
M_i_6 net_2 A2 VDD VDD pmos_6p0 W=1.830000U L=0.500000U
M_i_5 ZN A1 net_2 VDD pmos_6p0 W=1.830000U L=0.500000U
.ENDS
