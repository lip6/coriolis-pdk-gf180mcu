.SUBCKT gf180mcu_fd_sc_mcu9t5v0__oai211_2 A1 A2 B C ZN VDD VSS
*.PININFO A1:I A2:I B:I C:I ZN:O VDD:P VDD:P VSS:P VSS:G
*.EQN ZN=!(((A1 + A2) * B) * C)
M_i_1_1 ZN A2 net_0 VSS nmos_6p0 W=1.320000U L=0.600000U
M_i_0_1 net_0 A1 ZN VSS nmos_6p0 W=1.320000U L=0.600000U
M_i_0_0 ZN A1 net_0 VSS nmos_6p0 W=1.320000U L=0.600000U
M_i_1_0 net_0 A2 ZN VSS nmos_6p0 W=1.320000U L=0.600000U
M_i_2_0 net_1_0 B net_0 VSS nmos_6p0 W=1.320000U L=0.600000U
M_i_3_0 VSS C net_1_0 VSS nmos_6p0 W=1.320000U L=0.600000U
M_i_3_1 net_1_1 C VSS VSS nmos_6p0 W=1.320000U L=0.600000U
M_i_2_1 net_0 B net_1_1 VSS nmos_6p0 W=1.320000U L=0.600000U
M_i_5_1 net_2_0 A2 VDD VDD pmos_6p0 W=1.830000U L=0.500000U
M_i_4_1 ZN A1 net_2_0 VDD pmos_6p0 W=1.830000U L=0.500000U
M_i_4_0 net_2_1 A1 ZN VDD pmos_6p0 W=1.830000U L=0.500000U
M_i_5_0 VDD A2 net_2_1 VDD pmos_6p0 W=1.830000U L=0.500000U
M_i_6_0 ZN B VDD VDD pmos_6p0 W=1.460000U L=0.500000U
M_i_7_0 VDD C ZN VDD pmos_6p0 W=1.460000U L=0.500000U
M_i_7_1 ZN C VDD VDD pmos_6p0 W=1.460000U L=0.500000U
M_i_6_1 VDD B ZN VDD pmos_6p0 W=1.460000U L=0.500000U
.ENDS
