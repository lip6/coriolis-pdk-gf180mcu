.SUBCKT gf180mcu_fd_sc_mcu9t5v0__nand4_1 A1 A2 A3 A4 ZN VDD VSS
*.PININFO A1:I A2:I A3:I A4:I ZN:O VDD:P VDD:P VSS:P VSS:G
*.EQN ZN=!(((A1 * A2) * A3) * A4)
M_i_3 net_2 A4 VSS VSS nmos_6p0 W=1.320000U L=0.600000U
M_i_2 net_1 A3 net_2 VSS nmos_6p0 W=1.320000U L=0.600000U
M_i_1 net_0 A2 net_1 VSS nmos_6p0 W=1.320000U L=0.600000U
M_i_0 ZN A1 net_0 VSS nmos_6p0 W=1.320000U L=0.600000U
M_i_7 ZN A4 VDD VDD pmos_6p0 W=1.280000U L=0.500000U
M_i_6 VDD A3 ZN VDD pmos_6p0 W=1.280000U L=0.500000U
M_i_5 ZN A2 VDD VDD pmos_6p0 W=1.280000U L=0.500000U
M_i_4 VDD A1 ZN VDD pmos_6p0 W=1.280000U L=0.500000U
.ENDS
