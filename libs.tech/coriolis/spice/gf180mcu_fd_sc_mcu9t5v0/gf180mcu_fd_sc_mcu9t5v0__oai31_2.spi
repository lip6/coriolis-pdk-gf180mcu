.SUBCKT gf180mcu_fd_sc_mcu9t5v0__oai31_2 A1 A2 A3 B ZN VDD VSS
*.PININFO A1:I A2:I A3:I B:I ZN:O VDD:P VDD:P VSS:P VSS:G
*.EQN ZN=!(((A1 + A2) + A3) * B)
M_i_3_1 VSS B net_0 VSS nmos_6p0 W=1.320000U L=0.600000U
M_i_3_0 net_0 B VSS VSS nmos_6p0 W=1.320000U L=0.600000U
M_i_2_1 ZN A3 net_0 VSS nmos_6p0 W=1.320000U L=0.600000U
M_i_1_1 net_0 A2 ZN VSS nmos_6p0 W=1.320000U L=0.600000U
M_i_0_1 ZN A1 net_0 VSS nmos_6p0 W=1.320000U L=0.600000U
M_i_0_0 net_0 A1 ZN VSS nmos_6p0 W=1.320000U L=0.600000U
M_i_1_0 ZN A2 net_0 VSS nmos_6p0 W=1.320000U L=0.600000U
M_i_2_0 net_0 A3 ZN VSS nmos_6p0 W=1.320000U L=0.600000U
M_i_7_1 ZN B VDD VDD pmos_6p0 W=1.645000U L=0.500000U
M_i_7_0 VDD B ZN VDD pmos_6p0 W=1.645000U L=0.500000U
M_i_6_1 net_2_0 A3 VDD VDD pmos_6p0 W=1.830000U L=0.500000U
M_i_5_1 net_1_0 A2 net_2_0 VDD pmos_6p0 W=1.830000U L=0.500000U
M_i_4_1 ZN A1 net_1_0 VDD pmos_6p0 W=1.830000U L=0.500000U
M_i_4_0 net_1_1 A1 ZN VDD pmos_6p0 W=1.830000U L=0.500000U
M_i_5_0 net_2_1 A2 net_1_1 VDD pmos_6p0 W=1.830000U L=0.500000U
M_i_6_0 VDD A3 net_2_1 VDD pmos_6p0 W=1.830000U L=0.500000U
.ENDS
