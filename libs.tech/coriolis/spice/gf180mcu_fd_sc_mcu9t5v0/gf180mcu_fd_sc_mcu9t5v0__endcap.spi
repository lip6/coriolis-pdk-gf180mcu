.SUBCKT gf180mcu_fd_sc_mcu9t5v0__endcap VDD VSS
*.PININFO VDD:P VDD:P VSS:P VSS:G

.ENDS
