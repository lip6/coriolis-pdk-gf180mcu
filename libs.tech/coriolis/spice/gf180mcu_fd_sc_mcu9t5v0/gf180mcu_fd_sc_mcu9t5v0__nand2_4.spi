.SUBCKT gf180mcu_fd_sc_mcu9t5v0__nand2_4 A1 A2 ZN VDD VSS
*.PININFO A1:I A2:I ZN:O VDD:P VDD:P VSS:P VSS:G
*.EQN ZN=!(A1 * A2)
M_i_1_3 net_0_0 A2 VSS VSS nmos_6p0 W=1.320000U L=0.600000U
M_i_0_3 ZN A1 net_0_0 VSS nmos_6p0 W=1.320000U L=0.600000U
M_i_0_2 net_0_1 A1 ZN VSS nmos_6p0 W=1.320000U L=0.600000U
M_i_1_2 VSS A2 net_0_1 VSS nmos_6p0 W=1.320000U L=0.600000U
M_i_1_1 net_0_2 A2 VSS VSS nmos_6p0 W=1.320000U L=0.600000U
M_i_0_1 ZN A1 net_0_2 VSS nmos_6p0 W=1.320000U L=0.600000U
M_i_0_0 net_0_3 A1 ZN VSS nmos_6p0 W=1.320000U L=0.600000U
M_i_1_0 VSS A2 net_0_3 VSS nmos_6p0 W=1.320000U L=0.600000U
M_i_3_3 ZN A2 VDD VDD pmos_6p0 W=1.645000U L=0.500000U
M_i_2_3 VDD A1 ZN VDD pmos_6p0 W=1.645000U L=0.500000U
M_i_2_2 ZN A1 VDD VDD pmos_6p0 W=1.645000U L=0.500000U
M_i_3_2 VDD A2 ZN VDD pmos_6p0 W=1.645000U L=0.500000U
M_i_3_1 ZN A2 VDD VDD pmos_6p0 W=1.645000U L=0.500000U
M_i_2_1 VDD A1 ZN VDD pmos_6p0 W=1.645000U L=0.500000U
M_i_2_0 ZN A1 VDD VDD pmos_6p0 W=1.645000U L=0.500000U
M_i_3_0 VDD A2 ZN VDD pmos_6p0 W=1.645000U L=0.500000U
.ENDS
