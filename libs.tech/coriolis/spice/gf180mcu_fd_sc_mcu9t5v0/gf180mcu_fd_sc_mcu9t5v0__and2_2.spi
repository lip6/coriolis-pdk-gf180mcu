.SUBCKT gf180mcu_fd_sc_mcu9t5v0__and2_2 A1 A2 Z VDD VSS
*.PININFO A1:I A2:I Z:O VDD:P VDD:P VSS:P VSS:G
*.EQN Z=(A1 * A2)
M_i_2 net_0 A1 Z_neg VSS nmos_6p0 W=1.320000U L=0.600000U
M_i_3 VSS A2 net_0 VSS nmos_6p0 W=1.320000U L=0.600000U
M_i_0_0 Z Z_neg VSS VSS nmos_6p0 W=1.320000U L=0.600000U
M_i_0_1 VSS Z_neg Z VSS nmos_6p0 W=1.320000U L=0.600000U
M_i_4 Z_neg A1 VDD VDD pmos_6p0 W=1.640000U L=0.500000U
M_i_5 VDD A2 Z_neg VDD pmos_6p0 W=1.640000U L=0.500000U
M_i_1_0 Z Z_neg VDD VDD pmos_6p0 W=1.830000U L=0.500000U
M_i_1_1 VDD Z_neg Z VDD pmos_6p0 W=1.830000U L=0.500000U
.ENDS
