.SUBCKT gf180mcu_fd_sc_mcu9t5v0__buf_1 I Z VDD VSS
*.PININFO I:I Z:O VDD:P VDD:P VSS:P VSS:G
*.EQN Z=I
M_i_2 VSS I Z_neg VSS nmos_6p0 W=0.660000U L=0.600000U
M_i_0 Z Z_neg VSS VSS nmos_6p0 W=1.320000U L=0.600000U
M_i_3 VDD I Z_neg VDD pmos_6p0 W=0.915000U L=0.500000U
M_i_1 Z Z_neg VDD VDD pmos_6p0 W=1.830000U L=0.500000U
.ENDS
