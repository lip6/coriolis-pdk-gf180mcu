.SUBCKT gf180mcu_fd_sc_mcu9t5v0__nand2_1 A1 A2 ZN VDD VSS
*.PININFO A1:I A2:I ZN:O VDD:P VDD:P VSS:P VSS:G
*.EQN ZN=!(A1 * A2)
M_i_1 net_0 A2 VSS VSS nmos_6p0 W=1.320000U L=0.600000U
M_i_0 ZN A1 net_0 VSS nmos_6p0 W=1.320000U L=0.600000U
M_i_3 ZN A2 VDD VDD pmos_6p0 W=1.645000U L=0.500000U
M_i_2 VDD A1 ZN VDD pmos_6p0 W=1.645000U L=0.500000U
.ENDS
