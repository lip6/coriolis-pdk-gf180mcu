.SUBCKT gf180mcu_fd_sc_mcu9t5v0__fill_32 VDD VSS
*.PININFO VDD:P VDD:P VSS:P VSS:G
.ENDS
