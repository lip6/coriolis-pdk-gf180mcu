.SUBCKT gf180mcu_fd_sc_mcu9t5v0__invz_12 EN I ZN VDD VSS
*.PININFO EN:I I:I ZN:O VDD:P VDD:P VSS:P VSS:G
*.EQN ZN=!I
M_mn VSS EN NEN VSS nmos_6p0 W=1.320000U L=0.600000U
M_mn8 NI_N NEN VSS VSS nmos_6p0 W=1.320000U L=0.600000U
M_mn21 NI_P EN NI_N VSS nmos_6p0 W=1.320000U L=0.600000U
M_Mn_inv1 VSS I NI VSS nmos_6p0 W=1.320000U L=0.600000U
M_Mn_inv2 NI I VSS VSS nmos_6p0 W=1.320000U L=0.600000U
M_Mn_inv3 VSS I NI VSS nmos_6p0 W=1.320000U L=0.600000U
M_mn17 NI_N NI VSS VSS nmos_6p0 W=1.320000U L=0.600000U
M_mn17_9 VSS NI NI_N VSS nmos_6p0 W=1.320000U L=0.600000U
M_mn17_10 NI_N NI VSS VSS nmos_6p0 W=1.320000U L=0.600000U
M_mn17_9_17 VSS NI NI_N VSS nmos_6p0 W=1.320000U L=0.600000U
M_mn17_10_0 NI_N NI VSS VSS nmos_6p0 W=1.320000U L=0.600000U
M_mn17_9_17_30 VSS NI NI_N VSS nmos_6p0 W=1.320000U L=0.600000U
M_mn3_89 ZN NI_N VSS VSS nmos_6p0 W=1.320000U L=0.600000U
M_mn3_1_34 VSS NI_N ZN VSS nmos_6p0 W=1.320000U L=0.600000U
M_mn3_49_80 ZN NI_N VSS VSS nmos_6p0 W=1.320000U L=0.600000U
M_mn3_1_25_35 VSS NI_N ZN VSS nmos_6p0 W=1.320000U L=0.600000U
M_mn3 ZN NI_N VSS VSS nmos_6p0 W=1.320000U L=0.600000U
M_mn3_1 VSS NI_N ZN VSS nmos_6p0 W=1.320000U L=0.600000U
M_mn3_49 ZN NI_N VSS VSS nmos_6p0 W=1.320000U L=0.600000U
M_mn3_1_25 VSS NI_N ZN VSS nmos_6p0 W=1.320000U L=0.600000U
M_mn3_99 ZN NI_N VSS VSS nmos_6p0 W=1.320000U L=0.600000U
M_mn3_1_33 VSS NI_N ZN VSS nmos_6p0 W=1.320000U L=0.600000U
M_mn3_49_88 ZN NI_N VSS VSS nmos_6p0 W=1.320000U L=0.600000U
M_mn3_1_25_34 VSS NI_N ZN VSS nmos_6p0 W=1.320000U L=0.600000U
M_mp VDD EN NEN VDD pmos_6p0 W=1.800000U L=0.500000U
M_mp7 NI_P EN VDD VDD pmos_6p0 W=1.800000U L=0.500000U
M_mp22 NI_N NEN NI_P VDD pmos_6p0 W=1.800000U L=0.500000U
M_Mp_inv1 VDD I NI VDD pmos_6p0 W=1.800000U L=0.500000U
M_Mp_inv2 NI I VDD VDD pmos_6p0 W=1.800000U L=0.500000U
M_Mp_inv3 VDD I NI VDD pmos_6p0 W=1.800000U L=0.500000U
M_mp14 NI_P NI VDD VDD pmos_6p0 W=1.800000U L=0.500000U
M_mp14_10 VDD NI NI_P VDD pmos_6p0 W=1.800000U L=0.500000U
M_mp14_11 NI_P NI VDD VDD pmos_6p0 W=1.800000U L=0.500000U
M_mp14_10_8 VDD NI NI_P VDD pmos_6p0 W=1.800000U L=0.500000U
M_mp14_11_21 NI_P NI VDD VDD pmos_6p0 W=1.800000U L=0.500000U
M_mp14_10_8_17 VDD NI NI_P VDD pmos_6p0 W=1.800000U L=0.500000U
M_mp4_57 ZN NI_P VDD VDD pmos_6p0 W=1.800000U L=0.500000U
M_mp4_12_96 VDD NI_P ZN VDD pmos_6p0 W=1.800000U L=0.500000U
M_mp4_56_105 ZN NI_P VDD VDD pmos_6p0 W=1.800000U L=0.500000U
M_mp4_12_57_69 VDD NI_P ZN VDD pmos_6p0 W=1.800000U L=0.500000U
M_mp4 ZN NI_P VDD VDD pmos_6p0 W=1.800000U L=0.500000U
M_mp4_12 VDD NI_P ZN VDD pmos_6p0 W=1.800000U L=0.500000U
M_mp4_56 ZN NI_P VDD VDD pmos_6p0 W=1.800000U L=0.500000U
M_mp4_12_57 VDD NI_P ZN VDD pmos_6p0 W=1.800000U L=0.500000U
M_mp4_58 ZN NI_P VDD VDD pmos_6p0 W=1.800000U L=0.500000U
M_mp4_12_106 VDD NI_P ZN VDD pmos_6p0 W=1.800000U L=0.500000U
M_mp4_56_111 ZN NI_P VDD VDD pmos_6p0 W=1.800000U L=0.500000U
M_mp4_12_57_75 VDD NI_P ZN VDD pmos_6p0 W=1.800000U L=0.500000U
.ENDS
