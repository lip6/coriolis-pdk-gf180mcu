.SUBCKT gf180mcu_fd_sc_mcu9t5v0__oai32_1 A1 A2 A3 B1 B2 ZN VDD VSS
*.PININFO A1:I A2:I A3:I B1:I B2:I ZN:O VDD:P VDD:P VSS:P VSS:G
*.EQN ZN=!(((A1 + A2) + A3) * (B1 + B2))
M_i_4 net_0 A3 VSS VSS nmos_6p0 W=1.320000U L=0.600000U
M_i_3 VSS A2 net_0 VSS nmos_6p0 W=1.320000U L=0.600000U
M_i_2 net_0 A1 VSS VSS nmos_6p0 W=1.320000U L=0.600000U
M_i_0 ZN B1 net_0 VSS nmos_6p0 W=1.320000U L=0.600000U
M_i_1 net_0 B2 ZN VSS nmos_6p0 W=1.320000U L=0.600000U
M_i_9 net_3 A3 VDD VDD pmos_6p0 W=1.830000U L=0.500000U
M_i_8 net_2 A2 net_3 VDD pmos_6p0 W=1.830000U L=0.500000U
M_i_7 ZN A1 net_2 VDD pmos_6p0 W=1.830000U L=0.500000U
M_i_5 net_1 B1 ZN VDD pmos_6p0 W=1.830000U L=0.500000U
M_i_6 VDD B2 net_1 VDD pmos_6p0 W=1.830000U L=0.500000U
.ENDS
