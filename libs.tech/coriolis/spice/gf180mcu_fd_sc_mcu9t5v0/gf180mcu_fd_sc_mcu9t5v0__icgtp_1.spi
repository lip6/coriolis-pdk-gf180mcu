.SUBCKT gf180mcu_fd_sc_mcu9t5v0__icgtp_1 CLK E TE Q VDD VSS
*.PININFO CLK:I E:I TE:I Q:O VDD:P VDD:P VSS:P VSS:G
M_MU19 net50 TE VSS VSS nmos_6p0 W=0.700000U L=0.600000U
M_MU20 VSS E net50 VSS nmos_6p0 W=0.700000U L=0.600000U
M_MI82 net50 NCK net53 VSS nmos_6p0 W=0.700000U L=0.600000U
M_MI91 net53 CK net033 VSS nmos_6p0 W=0.700000U L=0.600000U
M_MI92 net033 QD VSS VSS nmos_6p0 W=0.700000U L=0.600000U
M_MI80_M_u2 VSS net53 QD VSS nmos_6p0 W=0.700000U L=0.600000U
M_MU82_M_u2 VSS NCK CK VSS nmos_6p0 W=0.700000U L=0.600000U
M_MU81_M_u2 NCK CLK VSS VSS nmos_6p0 W=0.700000U L=0.600000U
M_MI85_M_u3 XI85-net6 CLK d3 VSS nmos_6p0 W=0.700000U L=0.600000U
M_MI85_M_u4 VSS QD XI85-net6 VSS nmos_6p0 W=0.700000U L=0.600000U
M_MU75_M_u2 Q d3 VSS VSS nmos_6p0 W=1.000000U L=0.600000U
M_MI81 VDD TE net58 VDD pmos_6p0 W=1.380000U L=0.500000U
M_MU17 net58 E net61 VDD pmos_6p0 W=1.380000U L=0.500000U
M_MU16 net61 CK net53 VDD pmos_6p0 W=1.380000U L=0.500000U
M_MI90 net53 NCK net062 VDD pmos_6p0 W=1.380000U L=0.500000U
M_MI88 net062 QD VDD VDD pmos_6p0 W=1.380000U L=0.500000U
M_MI80_M_u3 VDD net53 QD VDD pmos_6p0 W=1.380000U L=0.500000U
M_MU82_M_u3 CK NCK VDD VDD pmos_6p0 W=1.380000U L=0.500000U
M_MU81_M_u3 VDD CLK NCK VDD pmos_6p0 W=1.380000U L=0.500000U
M_MI85_M_u1 d3 CLK VDD VDD pmos_6p0 W=1.380000U L=0.500000U
M_MI85_M_u2 VDD QD d3 VDD pmos_6p0 W=1.380000U L=0.500000U
M_MU75_M_u3 Q d3 VDD VDD pmos_6p0 W=1.830000U L=0.500000U
.ENDS
