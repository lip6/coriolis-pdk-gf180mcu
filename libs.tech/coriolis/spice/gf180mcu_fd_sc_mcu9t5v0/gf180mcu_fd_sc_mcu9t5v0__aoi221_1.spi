.SUBCKT gf180mcu_fd_sc_mcu9t5v0__aoi221_1 A1 A2 B1 B2 C ZN VDD VSS
*.PININFO A1:I A2:I B1:I B2:I C:I ZN:O VDD:P VDD:P VSS:P VSS:G
*.EQN ZN=!(((A1 * A2) + (B1 * B2)) + C)
M_i_4 net_1 B2 VSS VSS nmos_6p0 W=1.185000U L=0.600000U
M_i_3 ZN B1 net_1 VSS nmos_6p0 W=1.185000U L=0.600000U
M_i_2 VSS C ZN VSS nmos_6p0 W=0.790000U L=0.600000U
M_i_1 net_0 A2 VSS VSS nmos_6p0 W=1.185000U L=0.600000U
M_i_0 ZN A1 net_0 VSS nmos_6p0 W=1.185000U L=0.600000U
M_i_9 VDD B2 net_3 VDD pmos_6p0 W=1.830000U L=0.500000U
M_i_8 net_3 B1 VDD VDD pmos_6p0 W=1.830000U L=0.500000U
M_i_7 net_2 C net_3 VDD pmos_6p0 W=1.830000U L=0.500000U
M_i_6 ZN A2 net_2 VDD pmos_6p0 W=1.830000U L=0.500000U
M_i_5 net_2 A1 ZN VDD pmos_6p0 W=1.830000U L=0.500000U
.ENDS
