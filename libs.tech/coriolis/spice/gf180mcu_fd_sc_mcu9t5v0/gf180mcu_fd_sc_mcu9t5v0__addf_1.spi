.SUBCKT gf180mcu_fd_sc_mcu9t5v0__addf_1 A B CI CO S VDD VSS
*.PININFO A:I B:I CI:I CO:O S:O VDD:P VDD:P VSS:P VSS:G
*.EQN CO=(((B * CI) + (B * A)) + (CI * A));S=!((!((B * CI) + !(B + CI)) * A) + !(!((B * CI) + !(B + CI)) + A))
M_M51 VSS net9 S VSS nmos_6p0 W=1.180000U L=0.600000U
M_M50 net49 A VSS VSS nmos_6p0 W=0.590000U L=0.600000U
M_M48 net47 B net49 VSS nmos_6p0 W=0.590000U L=0.600000U
M_M46 net9 CI net47 VSS nmos_6p0 W=0.590000U L=0.600000U
M_M41 net9 net7 net42 VSS nmos_6p0 W=0.590000U L=0.600000U
M_M43 net42 A VSS VSS nmos_6p0 W=0.590000U L=0.600000U
M_M44 VSS B net42 VSS nmos_6p0 W=0.590000U L=0.600000U
M_M45 net42 CI VSS VSS nmos_6p0 W=0.590000U L=0.600000U
M_M40 VSS B net5 VSS nmos_6p0 W=0.590000U L=0.600000U
M_M39 net5 A VSS VSS nmos_6p0 W=0.590000U L=0.600000U
M_M38 net7 CI net5 VSS nmos_6p0 W=0.590000U L=0.600000U
M_M37 net36 B net7 VSS nmos_6p0 W=0.590000U L=0.600000U
M_M35 VSS A net36 VSS nmos_6p0 W=0.590000U L=0.600000U
M_M34 CO net7 VSS VSS nmos_6p0 W=1.320000U L=0.600000U
M_M33 VDD net9 S VDD pmos_6p0 W=1.830000U L=0.500000U
M_M32 net31 A VDD VDD pmos_6p0 W=0.990000U L=0.500000U
M_M30 net29 B net31 VDD pmos_6p0 W=0.990000U L=0.500000U
M_M28 net9 CI net29 VDD pmos_6p0 W=0.990000U L=0.500000U
M_M24 net9 net7 net3 VDD pmos_6p0 W=0.990000U L=0.500000U
M_M25 net3 A VDD VDD pmos_6p0 W=0.990000U L=0.500000U
M_M26 VDD B net3 VDD pmos_6p0 W=0.990000U L=0.500000U
M_M27 net3 CI VDD VDD pmos_6p0 W=0.990000U L=0.500000U
M_M23 VDD B net1 VDD pmos_6p0 W=0.990000U L=0.500000U
M_M22 net1 A VDD VDD pmos_6p0 W=0.990000U L=0.500000U
M_M21 net7 CI net1 VDD pmos_6p0 W=0.990000U L=0.500000U
M_M20 net19 B net7 VDD pmos_6p0 W=0.990000U L=0.500000U
M_M18 VDD A net19 VDD pmos_6p0 W=0.990000U L=0.500000U
M_M17 CO net7 VDD VDD pmos_6p0 W=1.830000U L=0.500000U
.ENDS
