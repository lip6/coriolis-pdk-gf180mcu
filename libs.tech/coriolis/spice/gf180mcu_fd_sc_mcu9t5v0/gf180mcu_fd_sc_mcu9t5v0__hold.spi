.SUBCKT gf180mcu_fd_sc_mcu9t5v0__hold Z VDD VSS
*.PININFO Z:B VDD:P VDD:P VSS:P VSS:G
M_u7 VDD Z net8 VDD pmos_6p0 W=1.830000U L=0.500000U
M_u3 VSS Z net8 VSS nmos_6p0 W=1.320000U L=0.600000U
M_MU12 Z net8 VDD VDD pmos_6p0 W=0.360000U L=2.00000U
M_MU11 Z net8 VSS VSS nmos_6p0 W=0.360000U L=2.00000U
.ENDS
