.SUBCKT gf180mcu_fd_sc_mcu9t5v0__or4_4 A1 A2 A3 A4 Z VDD VSS
*.PININFO A1:I A2:I A3:I A4:I Z:O VDD:P VDD:P VSS:P VSS:G
*.EQN Z=(((A1 + A2) + A3) + A4)
M_i_5_1_x2_1 Z_neg A4 VSS VSS nmos_6p0 W=0.790000U L=0.600000U
M_i_4_1_x2_1 VSS A3 Z_neg VSS nmos_6p0 W=0.790000U L=0.600000U
M_i_3_1_x2_1 Z_neg A2 VSS VSS nmos_6p0 W=0.790000U L=0.600000U
M_i_2_1_x2_1 VSS A1 Z_neg VSS nmos_6p0 W=0.790000U L=0.600000U
M_i_2_1_x2_0 Z_neg A1 VSS VSS nmos_6p0 W=0.790000U L=0.600000U
M_i_3_1_x2_0 VSS A2 Z_neg VSS nmos_6p0 W=0.790000U L=0.600000U
M_i_4_1_x2_0 Z_neg A3 VSS VSS nmos_6p0 W=0.790000U L=0.600000U
M_i_5_1_x2_0 VSS A4 Z_neg VSS nmos_6p0 W=0.790000U L=0.600000U
M_i_0_3_x4_3 Z Z_neg VSS VSS nmos_6p0 W=1.320000U L=0.600000U
M_i_0_3_x4_2 VSS Z_neg Z VSS nmos_6p0 W=1.320000U L=0.600000U
M_i_0_3_x4_1 Z Z_neg VSS VSS nmos_6p0 W=1.320000U L=0.600000U
M_i_0_3_x4_0 VSS Z_neg Z VSS nmos_6p0 W=1.320000U L=0.600000U
M_i_9_0_m2_1 net_2_0_1 A4 VDD VDD pmos_6p0 W=1.830000U L=0.500000U
M_i_8_0_m2_1 net_1_0_1 A3 net_2_0_1 VDD pmos_6p0 W=1.830000U L=0.500000U
M_i_7_0_m2_1 net_0_0_1 A2 net_1_0_1 VDD pmos_6p0 W=1.830000U L=0.500000U
M_i_6_0_m2_1 Z_neg A1 net_0_0_1 VDD pmos_6p0 W=1.830000U L=0.500000U
M_i_6_0_m2_0 net_0_0_0 A1 Z_neg VDD pmos_6p0 W=1.830000U L=0.500000U
M_i_7_0_m2_0 net_1_0_0 A2 net_0_0_0 VDD pmos_6p0 W=1.830000U L=0.500000U
M_i_8_0_m2_0 net_2_0_0 A3 net_1_0_0 VDD pmos_6p0 W=1.830000U L=0.500000U
M_i_9_0_m2_0 VDD A4 net_2_0_0 VDD pmos_6p0 W=1.830000U L=0.500000U
M_i_1_3_x4_3 Z Z_neg VDD VDD pmos_6p0 W=1.830000U L=0.500000U
M_i_1_3_x4_2 VDD Z_neg Z VDD pmos_6p0 W=1.830000U L=0.500000U
M_i_1_3_x4_1 Z Z_neg VDD VDD pmos_6p0 W=1.830000U L=0.500000U
M_i_1_3_x4_0 VDD Z_neg Z VDD pmos_6p0 W=1.830000U L=0.500000U
.ENDS
