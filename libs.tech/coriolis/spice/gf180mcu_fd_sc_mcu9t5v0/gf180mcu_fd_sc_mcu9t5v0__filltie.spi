.SUBCKT gf180mcu_fd_sc_mcu9t5v0__filltie VDD VSS
.ENDS
