.SUBCKT gf180mcu_fd_sc_mcu9t5v0__clkinv_8 I ZN VDD VSS
*.PININFO I:I ZN:O VDD:P VDD:P VSS:P VSS:G
*.EQN ZN=!I
M_i_0_0_x8_0 ZN I VSS VSS nmos_6p0 W=0.730000U L=0.600000U
M_i_0_0_x8_1 VSS I ZN VSS nmos_6p0 W=0.730000U L=0.600000U
M_i_0_0_x8_2 ZN I VSS VSS nmos_6p0 W=0.730000U L=0.600000U
M_i_0_0_x8_3 VSS I ZN VSS nmos_6p0 W=0.730000U L=0.600000U
M_i_0_0_x8_4 ZN I VSS VSS nmos_6p0 W=0.730000U L=0.600000U
M_i_0_0_x8_5 VSS I ZN VSS nmos_6p0 W=0.730000U L=0.600000U
M_i_0_0_x8_6 ZN I VSS VSS nmos_6p0 W=0.730000U L=0.600000U
M_i_0_0_x8_7 VSS I ZN VSS nmos_6p0 W=0.730000U L=0.600000U
M_i_1_0_x8_0 ZN I VDD VDD pmos_6p0 W=1.830000U L=0.500000U
M_i_1_0_x8_1 VDD I ZN VDD pmos_6p0 W=1.830000U L=0.500000U
M_i_1_0_x8_2 ZN I VDD VDD pmos_6p0 W=1.830000U L=0.500000U
M_i_1_0_x8_3 VDD I ZN VDD pmos_6p0 W=1.830000U L=0.500000U
M_i_1_0_x8_4 ZN I VDD VDD pmos_6p0 W=1.830000U L=0.500000U
M_i_1_0_x8_5 VDD I ZN VDD pmos_6p0 W=1.830000U L=0.500000U
M_i_1_0_x8_6 ZN I VDD VDD pmos_6p0 W=1.830000U L=0.500000U
M_i_1_0_x8_7 VDD I ZN VDD pmos_6p0 W=1.830000U L=0.500000U
.ENDS
