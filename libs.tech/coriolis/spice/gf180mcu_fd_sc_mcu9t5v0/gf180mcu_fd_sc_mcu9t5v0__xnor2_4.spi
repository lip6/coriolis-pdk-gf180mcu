.SUBCKT gf180mcu_fd_sc_mcu9t5v0__xnor2_4 A1 A2 ZN VDD VSS
*.PININFO A1:I A2:I ZN:O VDD:P VDD:P VSS:P VSS:G
*.EQN ZN=!(!((A1 * A2) + !(A1 + A2)))
M_i_8 I A2 VSS VSS nmos_6p0 W=0.360000U L=0.600000U
M_i_9 VSS A1 I VSS nmos_6p0 W=0.360000U L=0.600000U
M_i_4 Z_neg I VSS VSS nmos_6p0 W=1.320000U L=0.600000U
M_i_2 net_0 A1 Z_neg VSS nmos_6p0 W=1.320000U L=0.600000U
M_i_3 VSS A2 net_0 VSS nmos_6p0 W=1.320000U L=0.600000U
M_i_0_0 ZN Z_neg VSS VSS nmos_6p0 W=1.320000U L=0.600000U
M_i_0_1 VSS Z_neg ZN VSS nmos_6p0 W=1.320000U L=0.600000U
M_i_0_2 ZN Z_neg VSS VSS nmos_6p0 W=1.320000U L=0.600000U
M_i_0_3 VSS Z_neg ZN VSS nmos_6p0 W=1.320000U L=0.600000U
M_i_10 net_2 A2 I VDD pmos_6p0 W=0.495000U L=0.500000U
M_i_11 VDD A1 net_2 VDD pmos_6p0 W=0.495000U L=0.500000U
M_i_7 net_1 I VDD VDD pmos_6p0 W=1.830000U L=0.500000U
M_i_5 Z_neg A1 net_1 VDD pmos_6p0 W=1.830000U L=0.500000U
M_i_6 net_1 A2 Z_neg VDD pmos_6p0 W=1.830000U L=0.500000U
M_i_1_0 ZN Z_neg VDD VDD pmos_6p0 W=1.830000U L=0.500000U
M_i_1_1 VDD Z_neg ZN VDD pmos_6p0 W=1.830000U L=0.500000U
M_i_1_2 ZN Z_neg VDD VDD pmos_6p0 W=1.830000U L=0.500000U
M_i_1_3 VDD Z_neg ZN VDD pmos_6p0 W=1.830000U L=0.500000U
.ENDS
