.SUBCKT gf180mcu_fd_sc_mcu9t5v0__tieh Z VDD VSS
*.PININFO Z:O VDD:P VDD:P VSS:P VSS:G
M_n_tran_1 VSS A A VSS nmos_6p0 W=0.660000U L=0.600000U
M_p_tran_2 VDD A Z VDD pmos_6p0 W=0.900000U L=0.500000U
.ENDS
