.SUBCKT gf180mcu_fd_sc_mcu9t5v0__invz_3 EN I ZN VDD VSS
*.PININFO EN:I I:I ZN:O VDD:P VDD:P VSS:P VSS:G
*.EQN ZN=!I
M_mn VSS EN NEN VSS nmos_6p0 W=1.320000U L=0.600000U
M_mn8 NI_N NEN VSS VSS nmos_6p0 W=1.320000U L=0.600000U
M_mn21 NI_P EN NI_N VSS nmos_6p0 W=1.320000U L=0.600000U
M_Mn_inv VSS I NI VSS nmos_6p0 W=1.320000U L=0.600000U
M_mn17 NI_N NI VSS VSS nmos_6p0 W=0.885000U L=0.600000U
M_mn17_1 VSS NI NI_N VSS nmos_6p0 W=0.885000U L=0.600000U
M_mn3 ZN NI_N VSS VSS nmos_6p0 W=1.320000U L=0.600000U
M_mn3_1 VSS NI_N ZN VSS nmos_6p0 W=1.320000U L=0.600000U
M_mn3_2 ZN NI_N VSS VSS nmos_6p0 W=1.320000U L=0.600000U
M_mp VDD EN NEN VDD pmos_6p0 W=1.800000U L=0.500000U
M_mp7 NI_P EN VDD VDD pmos_6p0 W=1.800000U L=0.500000U
M_mp22 NI_N NEN NI_P VDD pmos_6p0 W=1.800000U L=0.500000U
M_Mp_inv VDD I NI VDD pmos_6p0 W=1.800000U L=0.500000U
M_mp14 NI_P NI VDD VDD pmos_6p0 W=1.485000U L=0.500000U
M_mp14_1 VDD NI NI_P VDD pmos_6p0 W=1.485000U L=0.500000U
M_mp4 ZN NI_P VDD VDD pmos_6p0 W=1.800000U L=0.500000U
M_mp4_1 VDD NI_P ZN VDD pmos_6p0 W=1.800000U L=0.500000U
M_mp4_2 ZN NI_P VDD VDD pmos_6p0 W=1.800000U L=0.500000U
.ENDS
