.SUBCKT gf180mcu_fd_sc_mcu9t5v0__latrnq_1 D E RN Q VDD VSS
*.PININFO D:I E:I RN:I Q:O VDD:P VDD:P VSS:P VSS:G
M_tn3 net7 E VSS VSS nmos_6p0 W=0.790000U L=0.600000U
M_tn10 net1 RN VSS VSS nmos_6p0 W=0.700000U L=0.600000U
M_tn9 net2 D net1 VSS nmos_6p0 W=0.700000U L=0.600000U
M_tn8 net2 E net3 VSS nmos_6p0 W=0.700000U L=0.600000U
M_tn7 net3 net7 net4 VSS nmos_6p0 W=0.700000U L=0.600000U
M_tn5 net5 net0 net4 VSS nmos_6p0 W=0.700000U L=0.600000U
M_tn0 VSS RN net5 VSS nmos_6p0 W=0.700000U L=0.600000U
M_tn6 net0 net3 VSS VSS nmos_6p0 W=0.790000U L=0.600000U
M_tn4 net6 net0 VSS VSS nmos_6p0 W=0.790000U L=0.600000U
M_tn1 Q net6 VSS VSS nmos_6p0 W=1.320000U L=0.600000U
M_tp2 net7 E VDD VDD pmos_6p0 W=1.380000U L=0.500000U
M_tp8 VDD RN net3 VDD pmos_6p0 W=1.000000U L=0.500000U
M_tp6 net8 D VDD VDD pmos_6p0 W=1.000000U L=0.500000U
M_tp5 net3 net7 net8 VDD pmos_6p0 W=1.000000U L=0.500000U
M_tp4 net9 E net3 VDD pmos_6p0 W=1.000000U L=0.500000U
M_tp3 net9 net0 VDD VDD pmos_6p0 W=1.000000U L=0.500000U
M_tp9 net0 net3 VDD VDD pmos_6p0 W=1.380000U L=0.500000U
M_tp7 net6 net0 VDD VDD pmos_6p0 W=1.380000U L=0.500000U
M_tp0 Q net6 VDD VDD pmos_6p0 W=1.830000U L=0.500000U
.ENDS
