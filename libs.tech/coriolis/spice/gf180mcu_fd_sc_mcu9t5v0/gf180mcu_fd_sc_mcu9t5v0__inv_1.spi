.SUBCKT gf180mcu_fd_sc_mcu9t5v0__inv_1 I ZN VDD VSS
*.PININFO I:I ZN:O VDD:P VDD:P VSS:P VSS:G
*.EQN ZN=!I
M_i_0 ZN I VSS VSS nmos_6p0 W=1.320000U L=0.600000U
M_i_1 ZN I VDD VDD pmos_6p0 W=1.830000U L=0.500000U
.ENDS
