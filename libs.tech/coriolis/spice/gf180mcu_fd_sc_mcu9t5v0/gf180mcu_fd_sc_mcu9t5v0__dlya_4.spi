.SUBCKT gf180mcu_fd_sc_mcu9t5v0__dlya_4 I Z VDD VSS
*.PININFO I:I Z:O VDD:P VDD:P VSS:P VSS:G
*.EQN Z=I
M_i_2_0 Z_neg I VSS VSS nmos_6p0 W=0.360000U L=0.600000U
M_i_2 VSS Z_neg net_2 VSS nmos_6p0 W=0.360000U L=0.600000U
M_i_3_6 net_3 net_2 VSS VSS nmos_6p0 W=0.360000U L=0.600000U
M_i_2_0_18 Z net_3 VSS VSS nmos_6p0 W=1.320000U L=0.600000U
M_i_2_0_18_1 Z net_3 VSS VSS nmos_6p0 W=1.320000U L=0.600000U
M_i_2_0_18_2 Z net_3 VSS VSS nmos_6p0 W=1.320000U L=0.600000U
M_i_2_0_18_1_15 Z net_3 VSS VSS nmos_6p0 W=1.320000U L=0.600000U
M_i_3_0 Z_neg I VDD VDD pmos_6p0 W=0.360000U L=0.500000U
M_i_1 VDD Z_neg net_2 VDD pmos_6p0 W=0.360000U L=0.500000U
M_i_0_29 net_3 net_2 VDD VDD pmos_6p0 W=0.360000U L=0.500000U
M_i_3_0_0 Z net_3 VDD VDD pmos_6p0 W=1.830000U L=0.500000U
M_i_3_0_0_14 Z net_3 VDD VDD pmos_6p0 W=1.830000U L=0.500000U
M_i_3_0_0_34 Z net_3 VDD VDD pmos_6p0 W=1.830000U L=0.500000U
M_i_3_0_0_14_19 Z net_3 VDD VDD pmos_6p0 W=1.830000U L=0.500000U
.ENDS
