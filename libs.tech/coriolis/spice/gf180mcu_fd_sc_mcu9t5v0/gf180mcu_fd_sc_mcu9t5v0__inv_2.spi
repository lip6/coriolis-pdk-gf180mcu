.SUBCKT gf180mcu_fd_sc_mcu9t5v0__inv_2 I ZN VDD VSS
*.PININFO I:I ZN:O VDD:P VDD:P VSS:P VSS:G
*.EQN ZN=!I
M_i_0_0 ZN I VSS VSS nmos_6p0 W=1.320000U L=0.600000U
M_i_0_1 VSS I ZN VSS nmos_6p0 W=1.320000U L=0.600000U
M_i_1_0 ZN I VDD VDD pmos_6p0 W=1.830000U L=0.500000U
M_i_1_1 VDD I ZN VDD pmos_6p0 W=1.830000U L=0.500000U
.ENDS
