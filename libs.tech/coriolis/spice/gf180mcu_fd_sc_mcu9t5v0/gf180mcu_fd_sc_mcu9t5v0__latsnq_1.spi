.SUBCKT gf180mcu_fd_sc_mcu9t5v0__latsnq_1 D E SETN Q VDD VSS
*.PININFO D:I E:I SETN:I Q:O VDD:P VDD:P VSS:P VSS:G
M_tn2 net6 E VSS VSS nmos_6p0 W=0.790000U L=0.600000U
M_tn7 VSS D net2 VSS nmos_6p0 W=0.700000U L=0.600000U
M_tn6 net3 E net2 VSS nmos_6p0 W=0.700000U L=0.600000U
M_tn5 net4 net6 net3 VSS nmos_6p0 W=0.700000U L=0.600000U
M_tn4 net4 net1 VSS VSS nmos_6p0 W=0.700000U L=0.600000U
M_tn9 VSS net3 net0 VSS nmos_6p0 W=0.790000U L=0.600000U
M_tn8 net0 SETN net1 VSS nmos_6p0 W=0.790000U L=0.600000U
M_tn3 net5 net1 VSS VSS nmos_6p0 W=0.790000U L=0.600000U
M_tn0 Q net5 VSS VSS nmos_6p0 W=1.320000U L=0.600000U
M_tp2 net6 E VDD VDD pmos_6p0 W=1.380000U L=0.500000U
M_tp6 VDD D net7 VDD pmos_6p0 W=1.000000U L=0.500000U
M_tp5 net7 net6 net3 VDD pmos_6p0 W=1.000000U L=0.500000U
M_tp4 net3 E net8 VDD pmos_6p0 W=1.000000U L=0.500000U
M_tp3 net8 net1 VDD VDD pmos_6p0 W=1.000000U L=0.500000U
M_tp9 VDD net3 net1 VDD pmos_6p0 W=1.380000U L=0.500000U
M_tp8 net1 SETN VDD VDD pmos_6p0 W=1.380000U L=0.500000U
M_tp7 net5 net1 VDD VDD pmos_6p0 W=1.380000U L=0.500000U
M_tp0 Q net5 VDD VDD pmos_6p0 W=1.830000U L=0.500000U
.ENDS
