.SUBCKT gf180mcu_fd_sc_mcu9t5v0__dffq_4 D CLK Q VDD VSS
*.PININFO D:I CLK:I Q:O VDD:P VDD:P VSS:P VSS:G
M_tn3 VSS CLK ncki VSS nmos_6p0 W=0.790000U L=0.600000U
M_tn4 cki ncki VSS VSS nmos_6p0 W=0.790000U L=0.600000U
M_tn5 net5 ncki VSS VSS nmos_6p0 W=0.580000U L=0.600000U
M_tn8 net4 D net5 VSS nmos_6p0 W=0.580000U L=0.600000U
M_tn6 net6 cki net4 VSS nmos_6p0 W=0.580000U L=0.600000U
M_tn7 VSS net0 net6 VSS nmos_6p0 W=0.580000U L=0.600000U
M_tn0 net0 net4 VSS VSS nmos_6p0 W=0.580000U L=0.600000U
M_tn9 net2 cki net0 VSS nmos_6p0 W=0.580000U L=0.600000U
M_tn11 net1 ncki net2 VSS nmos_6p0 W=0.580000U L=0.600000U
M_tn12 VSS net3 net1 VSS nmos_6p0 W=0.580000U L=0.600000U
M_tn10 net3 net2 VSS VSS nmos_6p0 W=1.320000U L=0.600000U
M_tn10_6 net3 net2 VSS VSS nmos_6p0 W=1.320000U L=0.600000U
M_tn1_39 Q net3 VSS VSS nmos_6p0 W=1.320000U L=0.600000U
M_tn1_18_47 Q net3 VSS VSS nmos_6p0 W=1.320000U L=0.600000U
M_tn1 Q net3 VSS VSS nmos_6p0 W=1.320000U L=0.600000U
M_tn1_18 Q net3 VSS VSS nmos_6p0 W=1.320000U L=0.600000U
M_tp3 VDD CLK ncki VDD pmos_6p0 W=1.380000U L=0.500000U
M_tp4 cki ncki VDD VDD pmos_6p0 W=1.380000U L=0.500000U
M_tp12 net7 cki VDD VDD pmos_6p0 W=1.000000U L=0.500000U
M_tp11 net4 D net7 VDD pmos_6p0 W=1.000000U L=0.500000U
M_tp6 net8 ncki net4 VDD pmos_6p0 W=1.000000U L=0.500000U
M_tp5 VDD net0 net8 VDD pmos_6p0 W=1.000000U L=0.500000U
M_tp0 net0 net4 VDD VDD pmos_6p0 W=1.000000U L=0.500000U
M_tp7 net2 ncki net0 VDD pmos_6p0 W=1.000000U L=0.500000U
M_tp9 net1x cki net2 VDD pmos_6p0 W=1.000000U L=0.500000U
M_tp10 VDD net3 net1x VDD pmos_6p0 W=1.000000U L=0.500000U
M_tp8 net3 net2 VDD VDD pmos_6p0 W=1.830000U L=0.500000U
M_tp8_10 net3 net2 VDD VDD pmos_6p0 W=1.830000U L=0.500000U
M_tp1_58 Q net3 VDD VDD pmos_6p0 W=1.830000U L=0.500000U
M_tp1_16_34 Q net3 VDD VDD pmos_6p0 W=1.830000U L=0.500000U
M_tp1 Q net3 VDD VDD pmos_6p0 W=1.830000U L=0.500000U
M_tp1_16 Q net3 VDD VDD pmos_6p0 W=1.830000U L=0.500000U
.ENDS
