.SUBCKT gf180mcu_fd_sc_mcu9t5v0__clkbuf_2 I Z VDD VSS
*.PININFO I:I Z:O VDD:P VDD:P VSS:P VSS:G
*.EQN Z=I
M_i_2 VSS I Z_neg VSS nmos_6p0 W=0.730000U L=0.600000U
M_i_0_0 Z Z_neg VSS VSS nmos_6p0 W=0.800000U L=0.600000U
M_i_0_1 VSS Z_neg Z VSS nmos_6p0 W=0.800000U L=0.600000U
M_i_3 VDD I Z_neg VDD pmos_6p0 W=1.830000U L=0.500000U
M_i_1_0 Z Z_neg VDD VDD pmos_6p0 W=1.830000U L=0.500000U
M_i_1_1 VDD Z_neg Z VDD pmos_6p0 W=1.830000U L=0.500000U
.ENDS
