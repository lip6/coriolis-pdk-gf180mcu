.SUBCKT gf180mcu_fd_sc_mcu9t5v0__xor2_2 A1 A2 Z VDD VSS
*.PININFO A1:I A2:I Z:O VDD:P VDD:P VSS:P VSS:G
*.EQN Z=!((A1 * A2) + !(A1 + A2))
M_i_8 net_2 A2 I VSS nmos_6p0 W=0.660000U L=0.600000U
M_i_9 VSS A1 net_2 VSS nmos_6p0 W=0.660000U L=0.600000U
M_i_4 net_0 I VSS VSS nmos_6p0 W=1.320000U L=0.600000U
M_i_2 Z_neg A1 net_0 VSS nmos_6p0 W=1.320000U L=0.600000U
M_i_3 net_0 A2 Z_neg VSS nmos_6p0 W=1.320000U L=0.600000U
M_i_0_0 Z Z_neg VSS VSS nmos_6p0 W=1.320000U L=0.600000U
M_i_0_1 VSS Z_neg Z VSS nmos_6p0 W=1.320000U L=0.600000U
M_i_10 I A2 VDD VDD pmos_6p0 W=0.915000U L=0.500000U
M_i_11 VDD A1 I VDD pmos_6p0 W=0.915000U L=0.500000U
M_i_7 Z_neg I VDD VDD pmos_6p0 W=1.830000U L=0.500000U
M_i_5 net_1 A1 Z_neg VDD pmos_6p0 W=1.830000U L=0.500000U
M_i_6 VDD A2 net_1 VDD pmos_6p0 W=1.830000U L=0.500000U
M_i_1_0 Z Z_neg VDD VDD pmos_6p0 W=1.830000U L=0.500000U
M_i_1_1 VDD Z_neg Z VDD pmos_6p0 W=1.830000U L=0.500000U
.ENDS
