.SUBCKT gf180mcu_fd_sc_mcu9t5v0__aoi21_2 A1 A2 B ZN VDD VSS
*.PININFO A1:I A2:I B:I ZN:O VDD:P VDD:P VSS:P VSS:G
*.EQN ZN=!((A1 * A2) + B)
M_i_2_0 ZN B VSS VSS nmos_6p0 W=0.920000U L=0.600000U
M_i_2_1 VSS B ZN VSS nmos_6p0 W=0.920000U L=0.600000U
M_i_1_0 net_0_0 A2 VSS VSS nmos_6p0 W=1.320000U L=0.600000U
M_i_0_1 ZN A1 net_0_0 VSS nmos_6p0 W=1.320000U L=0.600000U
M_i_0_0 net_0_1 A1 ZN VSS nmos_6p0 W=1.320000U L=0.600000U
M_i_1_1 VSS A2 net_0_1 VSS nmos_6p0 W=1.320000U L=0.600000U
M_i_5_0 VDD B net_1 VDD pmos_6p0 W=1.830000U L=0.500000U
M_i_5_1 net_1 B VDD VDD pmos_6p0 W=1.830000U L=0.500000U
M_i_4_0 ZN A2 net_1 VDD pmos_6p0 W=1.830000U L=0.500000U
M_i_3_1 net_1 A1 ZN VDD pmos_6p0 W=1.830000U L=0.500000U
M_i_3_0 ZN A1 net_1 VDD pmos_6p0 W=1.830000U L=0.500000U
M_i_4_1 net_1 A2 ZN VDD pmos_6p0 W=1.830000U L=0.500000U
.ENDS
