.SUBCKT gf180mcu_fd_sc_mcu9t5v0__or4_1 A1 A2 A3 A4 Z VDD VSS
*.PININFO A1:I A2:I A3:I A4:I Z:O VDD:P VDD:P VSS:P VSS:G
*.EQN Z=(((A1 + A2) + A3) + A4)
M_i_2 Z_neg A1 VSS VSS nmos_6p0 W=0.395000U L=0.600000U
M_i_3 VSS A2 Z_neg VSS nmos_6p0 W=0.395000U L=0.600000U
M_i_4 Z_neg A3 VSS VSS nmos_6p0 W=0.395000U L=0.600000U
M_i_5 VSS A4 Z_neg VSS nmos_6p0 W=0.395000U L=0.600000U
M_i_0 Z Z_neg VSS VSS nmos_6p0 W=1.320000U L=0.600000U
M_i_6 net_0 A1 Z_neg VDD pmos_6p0 W=0.915000U L=0.500000U
M_i_7 net_1 A2 net_0 VDD pmos_6p0 W=0.915000U L=0.500000U
M_i_8 net_2 A3 net_1 VDD pmos_6p0 W=0.915000U L=0.500000U
M_i_9 VDD A4 net_2 VDD pmos_6p0 W=0.915000U L=0.500000U
M_i_1 Z Z_neg VDD VDD pmos_6p0 W=1.830000U L=0.500000U
.ENDS
