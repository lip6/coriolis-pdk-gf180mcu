.SUBCKT gf180mcu_fd_sc_mcu9t5v0__mux4_2 I0 I1 I2 I3 S0 S1 Z VDD VSS
*.PININFO I0:I I1:I I2:I I3:I S0:I S1:I Z:O VDD:P VDD:P VSS:P VSS:G
*.EQN Z=((S0 * ((S1 * I3) + (!S1 * I1))) + (!S0 * ((S1 * I2) + (!S1 * I0))))
M_MN5 int01 I2 VSS VSS nmos_6p0 W=0.800000U L=0.600000U
M_MN9 int02 sel1_n int01 VSS nmos_6p0 W=0.800000U L=0.600000U
M_MN10 int07 S0 int02 VSS nmos_6p0 W=0.800000U L=0.600000U
M_MN6 VSS I3 int07 VSS nmos_6p0 W=0.800000U L=0.600000U
M_instance_22 Z int03 VSS VSS nmos_6p0 W=0.800000U L=0.600000U
M_instance_22_11 Z int03 VSS VSS nmos_6p0 W=0.800000U L=0.600000U
M_MN12 int03 S1 int02 VSS nmos_6p0 W=0.800000U L=0.600000U
M_MN11 int04 sel2_n int03 VSS nmos_6p0 W=0.800000U L=0.600000U
M_MN2 VSS S1 sel2_n VSS nmos_6p0 W=0.800000U L=0.600000U
M_MN4 int06 I1 VSS VSS nmos_6p0 W=0.800000U L=0.600000U
M_MN8 int04 S0 int06 VSS nmos_6p0 W=0.800000U L=0.600000U
M_MN7 int05 sel1_n int04 VSS nmos_6p0 W=0.800000U L=0.600000U
M_MN3 VSS I0 int05 VSS nmos_6p0 W=0.800000U L=0.600000U
M_MN1 sel1_n S0 VSS VSS nmos_6p0 W=0.800000U L=0.600000U
M_MP2 int01 I2 VDD VDD pmos_6p0 W=1.280000U L=0.500000U
M_MP9 int02 S0 int01 VDD pmos_6p0 W=1.280000U L=0.500000U
M_MP10 int07 sel1_n int02 VDD pmos_6p0 W=1.280000U L=0.500000U
M_MP6 VDD I3 int07 VDD pmos_6p0 W=1.280000U L=0.500000U
M_instance_1 Z int03 VDD VDD pmos_6p0 W=1.280000U L=0.500000U
M_instance_1_6 Z int03 VDD VDD pmos_6p0 W=1.280000U L=0.500000U
M_MP12 int03 sel2_n int02 VDD pmos_6p0 W=1.280000U L=0.500000U
M_MP11 int04 S1 int03 VDD pmos_6p0 W=1.280000U L=0.500000U
M_MP5 VDD S1 sel2_n VDD pmos_6p0 W=1.280000U L=0.500000U
M_MP4 int06 I1 VDD VDD pmos_6p0 W=1.280000U L=0.500000U
M_MP8 int04 sel1_n int06 VDD pmos_6p0 W=1.280000U L=0.500000U
M_MP7 int05 S0 int04 VDD pmos_6p0 W=1.280000U L=0.500000U
M_MP3 VDD I0 int05 VDD pmos_6p0 W=1.280000U L=0.500000U
M_MP1 sel1_n S0 VDD VDD pmos_6p0 W=1.280000U L=0.500000U
.ENDS
