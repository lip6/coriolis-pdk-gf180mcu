.SUBCKT gf180mcu_fd_sc_mcu9t5v0__fillcap_8 VDD VSS
*.PININFO VDD:P VDD:P VSS:P VSS:G
M_i_17 net_3 net_2 VSS VSS nmos_6p0 W=1.320000U L=1.000000U
M_i_17_23 net_4 net_5 VSS VSS nmos_6p0 W=1.320000U L=1.000000U
M_i_19 VDD net_3 net_2 VDD pmos_6p0 W=1.830000U L=1.000000U
M_i_19_7 VDD net_4 net_5 VDD pmos_6p0 W=1.830000U L=1.000000U
.ENDS
