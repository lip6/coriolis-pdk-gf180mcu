.SUBCKT gf180mcu_fd_sc_mcu9t5v0__fillcap_4 VDD VSS
*.PININFO VDD:P VDD:P VSS:P VSS:G
M_i_17 net_1 net_0 VSS VSS nmos_6p0 W=1.320000U L=1.000000U
M_i_19 VDD net_1 net_0 VDD pmos_6p0 W=1.830000U L=1.000000U
.ENDS
