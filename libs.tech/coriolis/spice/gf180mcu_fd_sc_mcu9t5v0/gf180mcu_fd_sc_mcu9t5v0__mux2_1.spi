.SUBCKT gf180mcu_fd_sc_mcu9t5v0__mux2_1 I0 I1 S Z VDD VSS
*.PININFO I0:I I1:I S:I Z:O VDD:P VDD:P VSS:P VSS:G
*.EQN Z=((S * I1) + (!S * I0))
M_MN2 VSS int04 Z VSS nmos_6p0 W=1.320000U L=0.600000U
M_MN4 net_1 I1 VSS VSS nmos_6p0 W=0.660000U L=0.600000U
M_MN8 int04 S net_1 VSS nmos_6p0 W=0.660000U L=0.600000U
M_MN7 net_3 sel1_n int04 VSS nmos_6p0 W=0.660000U L=0.600000U
M_MN3 VSS I0 net_3 VSS nmos_6p0 W=0.660000U L=0.600000U
M_MN1 sel1_n S VSS VSS nmos_6p0 W=0.660000U L=0.600000U
M_MP5 VDD int04 Z VDD pmos_6p0 W=1.830000U L=0.500000U
M_MP4 net_0 I1 VDD VDD pmos_6p0 W=0.915000U L=0.500000U
M_MP8 int04 sel1_n net_0 VDD pmos_6p0 W=0.915000U L=0.500000U
M_MP7 net_2 S int04 VDD pmos_6p0 W=0.915000U L=0.500000U
M_MP3 VDD I0 net_2 VDD pmos_6p0 W=0.915000U L=0.500000U
M_MP1 sel1_n S VDD VDD pmos_6p0 W=0.915000U L=0.500000U
.ENDS
