.SUBCKT gf180mcu_fd_sc_mcu9t5v0__fillcap_16 VDD VSS
*.PININFO VDD:P VDD:P VSS:P VSS:G
M_i_17 net_3 net_2 VSS VSS nmos_6p0 W=1.320000U L=1.000000U
M_i_17_23 net_4 net_5 VSS VSS nmos_6p0 W=1.320000U L=1.000000U
M_i_17_24 net_7 net_9 VSS VSS nmos_6p0 W=1.320000U L=1.000000U
M_i_17_23_55 net_6 net_8 VSS VSS nmos_6p0 W=1.320000U L=1.000000U
M_i_19 VDD net_3 net_2 VDD pmos_6p0 W=1.830000U L=1.000000U
M_i_19_7 VDD net_4 net_5 VDD pmos_6p0 W=1.830000U L=1.000000U
M_i_19_33 VDD net_7 net_9 VDD pmos_6p0 W=1.830000U L=1.000000U
M_i_19_7_23 VDD net_6 net_8 VDD pmos_6p0 W=1.830000U L=1.000000U
.ENDS
