.SUBCKT gf180mcu_fd_sc_mcu9t5v0__nor2_1 A1 A2 ZN VDD VSS
*.PININFO A1:I A2:I ZN:O VDD:P VDD:P VSS:P VSS:G
*.EQN ZN=!(A1 + A2)
M_i_1 ZN A2 VSS VSS nmos_6p0 W=0.920000U L=0.600000U
M_i_0 VSS A1 ZN VSS nmos_6p0 W=0.920000U L=0.600000U
M_i_3 net_0 A2 VDD VDD pmos_6p0 W=1.830000U L=0.500000U
M_i_2 ZN A1 net_0 VDD pmos_6p0 W=1.830000U L=0.500000U
.ENDS
