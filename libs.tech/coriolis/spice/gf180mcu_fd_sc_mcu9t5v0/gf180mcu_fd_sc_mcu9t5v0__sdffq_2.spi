.SUBCKT gf180mcu_fd_sc_mcu9t5v0__sdffq_2 D SE SI CLK Q VDD VSS
*.PININFO D:I SE:I SI:I CLK:I Q:O VDD:P VDD:P VSS:P VSS:G
M_tn14 net8 SE VSS VSS nmos_6p0 W=0.580000U L=0.600000U
M_tn12 net12 SI VSS VSS nmos_6p0 W=0.580000U L=0.600000U
M_tn13 net12 SE net6 VSS nmos_6p0 W=0.580000U L=0.600000U
M_tn8 net6 net8 net9n VSS nmos_6p0 W=0.580000U L=0.600000U
M_tn10 VSS D net9n VSS nmos_6p0 W=0.580000U L=0.600000U
M_tn16 ncki CLK VSS VSS nmos_6p0 W=0.790000U L=0.600000U
M_tn9 cki ncki VSS VSS nmos_6p0 W=0.790000U L=0.600000U
M_tn11 net6 ncki net5 VSS nmos_6p0 W=0.580000U L=0.600000U
M_tn0 net5 cki net11 VSS nmos_6p0 W=0.580000U L=0.600000U
M_tn1 VSS net10 net11 VSS nmos_6p0 W=0.580000U L=0.600000U
M_tn15 net10 net5 VSS VSS nmos_6p0 W=0.580000U L=0.600000U
M_tn2 net0 cki net10 VSS nmos_6p0 W=0.580000U L=0.600000U
M_tn3 net7 ncki net0 VSS nmos_6p0 W=0.580000U L=0.600000U
M_tn4 VSS net1 net7 VSS nmos_6p0 W=1.320000U L=0.600000U
M_tn5 net1 net0 VSS VSS nmos_6p0 W=1.320000U L=0.600000U
M_tn6_6 Q net1 VSS VSS nmos_6p0 W=1.320000U L=0.600000U
M_tn6 Q net1 VSS VSS nmos_6p0 W=1.320000U L=0.600000U
M_tp14 net8 SE VDD VDD pmos_6p0 W=1.000000U L=0.500000U
M_tp13 net3 SI VDD VDD pmos_6p0 W=1.000000U L=0.500000U
M_tp12 net2 net8 net3 VDD pmos_6p0 W=1.000000U L=0.500000U
M_tp8 net9p SE net2 VDD pmos_6p0 W=1.000000U L=0.500000U
M_tp10 VDD D net9p VDD pmos_6p0 W=1.000000U L=0.500000U
M_tp16 ncki CLK VDD VDD pmos_6p0 W=1.380000U L=0.500000U
M_tp9 cki ncki VDD VDD pmos_6p0 W=1.380000U L=0.500000U
M_tp11 net5 cki net2 VDD pmos_6p0 W=1.000000U L=0.500000U
M_tp0 net4 ncki net5 VDD pmos_6p0 W=1.000000U L=0.500000U
M_tp1 VDD net10 net4 VDD pmos_6p0 W=1.000000U L=0.500000U
M_tp15 net10 net5 VDD VDD pmos_6p0 W=1.000000U L=0.500000U
M_tp7 net0 ncki net10 VDD pmos_6p0 W=1.000000U L=0.500000U
M_tp6 net7_p cki net0 VDD pmos_6p0 W=1.000000U L=0.500000U
M_tp2 VDD net1 net7_p VDD pmos_6p0 W=1.830000U L=0.500000U
M_tp3 net1 net0 VDD VDD pmos_6p0 W=1.830000U L=0.500000U
M_tp4_12 Q net1 VDD VDD pmos_6p0 W=1.830000U L=0.500000U
M_tp4 Q net1 VDD VDD pmos_6p0 W=1.830000U L=0.500000U
.ENDS
