.SUBCKT gf180mcu_fd_sc_mcu9t5v0__latrsnq_2 D E RN SETN Q VDD VSS
*.PININFO D:I E:I RN:I SETN:I Q:O VDD:P VDD:P VSS:P VSS:G
M_tn3 net8 E VSS VSS nmos_6p0 W=0.790000U L=0.600000U
M_tn9 net2 RN VSS VSS nmos_6p0 W=0.700000U L=0.600000U
M_tn8 net3 D net2 VSS nmos_6p0 W=0.700000U L=0.600000U
M_tn7 net3 E net4 VSS nmos_6p0 W=0.700000U L=0.600000U
M_tn6 net4 net8 net5 VSS nmos_6p0 W=0.700000U L=0.600000U
M_tn5 net6 net1 net5 VSS nmos_6p0 W=0.700000U L=0.600000U
M_tn0 VSS RN net6 VSS nmos_6p0 W=0.700000U L=0.600000U
M_tn11 VSS net4 net0 VSS nmos_6p0 W=0.790000U L=0.600000U
M_tn10 net0 SETN net1 VSS nmos_6p0 W=0.790000U L=0.600000U
M_tn4 net7 net1 VSS VSS nmos_6p0 W=1.320000U L=0.600000U
M_tn1 Q net7 VSS VSS nmos_6p0 W=1.320000U L=0.600000U
M_tn1_19 Q net7 VSS VSS nmos_6p0 W=1.320000U L=0.600000U
M_tp2 net8 E VDD VDD pmos_6p0 W=1.380000U L=0.600000U
M_tp8 VDD RN net4 VDD pmos_6p0 W=1.000000U L=0.600000U
M_tp6 net9 D VDD VDD pmos_6p0 W=1.000000U L=0.600000U
M_tp5 net4 net8 net9 VDD pmos_6p0 W=1.000000U L=0.600000U
M_tp4 net10 E net4 VDD pmos_6p0 W=1.000000U L=0.600000U
M_tp3 net10 net1 VDD VDD pmos_6p0 W=1.000000U L=0.600000U
M_tp10 VDD net4 net1 VDD pmos_6p0 W=1.000000U L=0.600000U
M_tp9 net1 SETN VDD VDD pmos_6p0 W=1.380000U L=0.600000U
M_tp7 net7 net1 VDD VDD pmos_6p0 W=1.830000U L=0.600000U
M_tp0 Q net7 VDD VDD pmos_6p0 W=1.830000U L=0.600000U
M_tp0_9 Q net7 VDD VDD pmos_6p0 W=1.830000U L=0.600000U
.ENDS
