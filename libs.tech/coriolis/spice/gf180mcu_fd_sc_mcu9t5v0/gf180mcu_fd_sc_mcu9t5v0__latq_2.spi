.SUBCKT gf180mcu_fd_sc_mcu9t5v0__latq_2 D E Q VDD VSS
*.PININFO D:I E:I Q:O VDD:P VDD:P VSS:P VSS:G
M_tn0 VSS E net4 VSS nmos_6p0 W=0.790000U L=0.600000U
M_tn8 net7 net4 VSS VSS nmos_6p0 W=0.700000U L=0.600000U
M_tn4 VSS D net3 VSS nmos_6p0 W=0.700000U L=0.600000U
M_tn5 net5 net7 net3 VSS nmos_6p0 W=0.700000U L=0.600000U
M_tn1 net2 net4 net5 VSS nmos_6p0 W=0.700000U L=0.600000U
M_tn2 net2 net6 VSS VSS nmos_6p0 W=0.790000U L=0.600000U
M_tn3 net6 net5 VSS VSS nmos_6p0 W=0.790000U L=0.600000U
M_tn6_30 Q net5 VSS VSS nmos_6p0 W=1.320000U L=0.600000U
M_tn6 Q net5 VSS VSS nmos_6p0 W=1.320000U L=0.600000U
M_tp0 VDD E net4 VDD pmos_6p0 W=1.380000U L=0.500000U
M_tp8 net7 net4 VDD VDD pmos_6p0 W=1.000000U L=0.500000U
M_tp5 VDD D net1 VDD pmos_6p0 W=1.000000U L=0.500000U
M_tp4 net1 net4 net5 VDD pmos_6p0 W=1.000000U L=0.500000U
M_tp2 net5 net7 net0 VDD pmos_6p0 W=1.000000U L=0.500000U
M_tp1 net0 net6 VDD VDD pmos_6p0 W=1.380000U L=0.500000U
M_tp3 net6 net5 VDD VDD pmos_6p0 W=1.380000U L=0.500000U
M_tp6_31 Q net5 VDD VDD pmos_6p0 W=1.830000U L=0.500000U
M_tp6 Q net5 VDD VDD pmos_6p0 W=1.830000U L=0.500000U
.ENDS
