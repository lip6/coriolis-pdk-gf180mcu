.SUBCKT gf180mcu_fd_sc_mcu9t5v0__icgtn_4 CLKN E TE Q VDD VSS
*.PININFO CLKN:I E:I TE:I Q:O VDD:P VDD:P VSS:P VSS:G
M_MU19 VSS TE net50 VSS nmos_6p0 W=0.700000U L=0.600000U
M_MU20 net50 E VSS VSS nmos_6p0 W=0.700000U L=0.600000U
M_MI82 net53 NCP net50 VSS nmos_6p0 W=0.700000U L=0.600000U
M_MI91 net038 CP net53 VSS nmos_6p0 W=0.700000U L=0.600000U
M_MI92 VSS QD net038 VSS nmos_6p0 W=0.700000U L=0.600000U
M_MU82_M_u2 NCP CP VSS VSS nmos_6p0 W=0.700000U L=0.600000U
M_MI95_M_u2 VSS net53 QD VSS nmos_6p0 W=0.700000U L=0.600000U
M_MI89_M_u2 net36 QD VSS VSS nmos_6p0 W=0.700000U L=0.600000U
M_MU81_M_u2 VSS CLKN CP VSS nmos_6p0 W=0.800000U L=0.600000U
M_MI1_M_u3 d3 net36 VSS VSS nmos_6p0 W=0.800000U L=0.600000U
M_MI1_M_u4 VSS CLKN d3 VSS nmos_6p0 W=0.800000U L=0.600000U
M_MU75_M_u2 Q d3 VSS VSS nmos_6p0 W=1.000000U L=0.600000U
M_MU75_M_u2_19 Q d3 VSS VSS nmos_6p0 W=1.000000U L=0.600000U
M_MU75_M_u2_33 Q d3 VSS VSS nmos_6p0 W=1.000000U L=0.600000U
M_MU75_M_u2_19_5 Q d3 VSS VSS nmos_6p0 W=1.000000U L=0.600000U
M_MI81 net58 TE VDD VDD pmos_6p0 W=1.380000U L=0.500000U
M_MU17 net61 E net58 VDD pmos_6p0 W=1.380000U L=0.500000U
M_MU16 net53 CP net61 VDD pmos_6p0 W=1.380000U L=0.500000U
M_MI90 net067 NCP net53 VDD pmos_6p0 W=1.380000U L=0.500000U
M_MI88 VDD QD net067 VDD pmos_6p0 W=1.380000U L=0.500000U
M_MU82_M_u3 NCP CP VDD VDD pmos_6p0 W=1.380000U L=0.500000U
M_MI95_M_u3 VDD net53 QD VDD pmos_6p0 W=1.380000U L=0.500000U
M_MI89_M_u3 net36 QD VDD VDD pmos_6p0 W=1.380000U L=0.500000U
M_MU81_M_u3 VDD CLKN CP VDD pmos_6p0 W=1.680000U L=0.500000U
M_MI1_M_u1 XI1-net8 net36 VDD VDD pmos_6p0 W=1.680000U L=0.500000U
M_MI1_M_u2 d3 CLKN XI1-net8 VDD pmos_6p0 W=1.680000U L=0.500000U
M_MU75_M_u3 Q d3 VDD VDD pmos_6p0 W=1.830000U L=0.500000U
M_MU75_M_u3_1 Q d3 VDD VDD pmos_6p0 W=1.830000U L=0.500000U
M_MU75_M_u3_2 Q d3 VDD VDD pmos_6p0 W=1.830000U L=0.500000U
M_MU75_M_u3_1_35 Q d3 VDD VDD pmos_6p0 W=1.830000U L=0.500000U
.ENDS
