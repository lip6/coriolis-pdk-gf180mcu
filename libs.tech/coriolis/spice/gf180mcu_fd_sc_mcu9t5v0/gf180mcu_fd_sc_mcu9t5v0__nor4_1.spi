.SUBCKT gf180mcu_fd_sc_mcu9t5v0__nor4_1 A1 A2 A3 A4 ZN VDD VSS
*.PININFO A1:I A2:I A3:I A4:I ZN:O VDD:P VDD:P VSS:P VSS:G
*.EQN ZN=!(((A1 + A2) + A3) + A4)
M_i_3 ZN A4 VSS VSS nmos_6p0 W=0.660000U L=0.600000U
M_i_2 VSS A3 ZN VSS nmos_6p0 W=0.660000U L=0.600000U
M_i_1 ZN A2 VSS VSS nmos_6p0 W=0.660000U L=0.600000U
M_i_0 VSS A1 ZN VSS nmos_6p0 W=0.660000U L=0.600000U
M_i_7 net_2 A4 VDD VDD pmos_6p0 W=1.830000U L=0.500000U
M_i_6 net_1 A3 net_2 VDD pmos_6p0 W=1.830000U L=0.500000U
M_i_5 net_0 A2 net_1 VDD pmos_6p0 W=1.830000U L=0.500000U
M_i_4 ZN A1 net_0 VDD pmos_6p0 W=1.830000U L=0.500000U
.ENDS
