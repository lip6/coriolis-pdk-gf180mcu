.SUBCKT gf180mcu_fd_sc_mcu9t5v0__xor2_1 A1 A2 Z VDD VSS
*.PININFO A1:I A2:I Z:O VDD:P VDD:P VSS:P VSS:G
*.EQN Z=!((A1 * A2) + !(A1 + A2))
M_i_6 I A2 VSS VSS nmos_6p0 W=0.660000U L=0.600000U
M_i_7 VSS A1 I VSS nmos_6p0 W=0.660000U L=0.600000U
M_i_2 Z I VSS VSS nmos_6p0 W=1.320000U L=0.600000U
M_i_0 net_0 A1 Z VSS nmos_6p0 W=1.320000U L=0.600000U
M_i_1 VSS A2 net_0 VSS nmos_6p0 W=1.320000U L=0.600000U
M_i_8 net_2 A2 I VDD pmos_6p0 W=0.915000U L=0.500000U
M_i_9 VDD A1 net_2 VDD pmos_6p0 W=0.915000U L=0.500000U
M_i_5 net_1 I VDD VDD pmos_6p0 W=1.830000U L=0.500000U
M_i_3 Z A1 net_1 VDD pmos_6p0 W=1.830000U L=0.500000U
M_i_4 net_1 A2 Z VDD pmos_6p0 W=1.830000U L=0.500000U
.ENDS
