.SUBCKT gf180mcu_fd_sc_mcu9t5v0__aoi211_2 A1 A2 B C ZN VDD VSS
*.PININFO A1:I A2:I B:I C:I ZN:O VDD:P VDD:P VSS:P VSS:G
*.EQN ZN=!(((A1 * A2) + B) + C)
M_i_1_1 net_0_0 A2 VSS VSS nmos_6p0 W=1.185000U L=0.600000U
M_i_0_1 ZN A1 net_0_0 VSS nmos_6p0 W=1.185000U L=0.600000U
M_i_0_0 net_0_1 A1 ZN VSS nmos_6p0 W=1.185000U L=0.600000U
M_i_1_0 VSS A2 net_0_1 VSS nmos_6p0 W=1.185000U L=0.600000U
M_i_2_0 ZN B VSS VSS nmos_6p0 W=0.790000U L=0.600000U
M_i_3_0 VSS C ZN VSS nmos_6p0 W=0.790000U L=0.600000U
M_i_3_1 ZN C VSS VSS nmos_6p0 W=0.790000U L=0.600000U
M_i_2_1 VSS B ZN VSS nmos_6p0 W=0.790000U L=0.600000U
M_i_5_1 ZN A2 net_1 VDD pmos_6p0 W=1.830000U L=0.500000U
M_i_4_1 net_1 A1 ZN VDD pmos_6p0 W=1.830000U L=0.500000U
M_i_4_0 ZN A1 net_1 VDD pmos_6p0 W=1.830000U L=0.500000U
M_i_5_0 net_1 A2 ZN VDD pmos_6p0 W=1.830000U L=0.500000U
M_i_6_0 net_2_0 B net_1 VDD pmos_6p0 W=1.830000U L=0.500000U
M_i_7_0 VDD C net_2_0 VDD pmos_6p0 W=1.830000U L=0.500000U
M_i_7_1 net_2_1 C VDD VDD pmos_6p0 W=1.830000U L=0.500000U
M_i_6_1 net_1 B net_2_1 VDD pmos_6p0 W=1.830000U L=0.500000U
.ENDS
