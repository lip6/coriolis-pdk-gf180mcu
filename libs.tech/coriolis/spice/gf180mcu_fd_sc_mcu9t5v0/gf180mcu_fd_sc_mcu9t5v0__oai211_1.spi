.SUBCKT gf180mcu_fd_sc_mcu9t5v0__oai211_1 A1 A2 B C ZN VDD VSS
*.PININFO A1:I A2:I B:I C:I ZN:O VDD:P VDD:P VSS:P VSS:G
*.EQN ZN=!(((A1 + A2) * B) * C)
M_i_1 ZN A2 net_0 VSS nmos_6p0 W=1.320000U L=0.600000U
M_i_0 net_0 A1 ZN VSS nmos_6p0 W=1.320000U L=0.600000U
M_i_2 net_1 B net_0 VSS nmos_6p0 W=1.320000U L=0.600000U
M_i_3 VSS C net_1 VSS nmos_6p0 W=1.320000U L=0.600000U
M_i_5 net_2 A2 VDD VDD pmos_6p0 W=1.830000U L=0.500000U
M_i_4 ZN A1 net_2 VDD pmos_6p0 W=1.830000U L=0.500000U
M_i_6 VDD B ZN VDD pmos_6p0 W=1.460000U L=0.500000U
M_i_7 ZN C VDD VDD pmos_6p0 W=1.460000U L=0.500000U
.ENDS
