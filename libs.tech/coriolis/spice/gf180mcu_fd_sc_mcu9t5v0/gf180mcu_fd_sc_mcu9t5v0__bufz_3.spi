.SUBCKT gf180mcu_fd_sc_mcu9t5v0__bufz_3 EN I Z VDD VSS
*.PININFO EN:I I:I Z:O VDD:P VDD:P VSS:P VSS:G
*.EQN Z=I
M_XX27 VSS EN NEN VSS nmos_6p0 W=1.320000U L=0.600000U
M_XX44 VSS NEN NI_N VSS nmos_6p0 W=1.320000U L=0.600000U
M_XX36 NI_N EN NI_P VSS nmos_6p0 W=1.320000U L=0.600000U
M_XX43 NI_N I VSS VSS nmos_6p0 W=0.885000U L=0.600000U
M_XX43_17 NI_N I VSS VSS nmos_6p0 W=0.885000U L=0.600000U
M_XX22 Z NI_N VSS VSS nmos_6p0 W=1.320000U L=0.600000U
M_XX22_4 Z NI_N VSS VSS nmos_6p0 W=1.320000U L=0.600000U
M_XX22_4_97 Z NI_N VSS VSS nmos_6p0 W=1.320000U L=0.600000U
M_XX28 VDD EN NEN VDD pmos_6p0 W=1.800000U L=0.500000U
M_XX45 NI_P EN VDD VDD pmos_6p0 W=1.800000U L=0.500000U
M_XX39 NI_N NEN NI_P VDD pmos_6p0 W=1.800000U L=0.500000U
M_XX46 NI_P I VDD VDD pmos_6p0 W=1.485000U L=0.500000U
M_XX46_9 NI_P I VDD VDD pmos_6p0 W=1.485000U L=0.500000U
M_XX21 VDD NI_P Z VDD pmos_6p0 W=1.800000U L=0.500000U
M_XX21_5 VDD NI_P Z VDD pmos_6p0 W=1.800000U L=0.500000U
M_XX21_5_72 VDD NI_P Z VDD pmos_6p0 W=1.800000U L=0.500000U
.ENDS
