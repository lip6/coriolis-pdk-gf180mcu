.SUBCKT gf180mcu_fd_sc_mcu9t5v0__nand4_2 A1 A2 A3 A4 ZN VDD VSS
*.PININFO A1:I A2:I A3:I A4:I ZN:O VDD:P VDD:P VSS:P VSS:G
*.EQN ZN=!(((A1 * A2) * A3) * A4)
M_i_3_0 net_2_0 A4 VSS VSS nmos_6p0 W=1.320000U L=0.600000U
M_i_2_0 net_1_0 A3 net_2_0 VSS nmos_6p0 W=1.320000U L=0.600000U
M_i_1_0 net_0_0 A2 net_1_0 VSS nmos_6p0 W=1.320000U L=0.600000U
M_i_0_0 ZN A1 net_0_0 VSS nmos_6p0 W=1.320000U L=0.600000U
M_i_0_1 net_0_1 A1 ZN VSS nmos_6p0 W=1.320000U L=0.600000U
M_i_1_1 net_1_1 A2 net_0_1 VSS nmos_6p0 W=1.320000U L=0.600000U
M_i_2_1 net_2_1 A3 net_1_1 VSS nmos_6p0 W=1.320000U L=0.600000U
M_i_3_1 VSS A4 net_2_1 VSS nmos_6p0 W=1.320000U L=0.600000U
M_i_7_0 VDD A4 ZN VDD pmos_6p0 W=1.280000U L=0.500000U
M_i_6_0 ZN A3 VDD VDD pmos_6p0 W=1.280000U L=0.500000U
M_i_5_0 VDD A2 ZN VDD pmos_6p0 W=1.280000U L=0.500000U
M_i_4_0 ZN A1 VDD VDD pmos_6p0 W=1.280000U L=0.500000U
M_i_4_1 VDD A1 ZN VDD pmos_6p0 W=1.280000U L=0.500000U
M_i_5_1 ZN A2 VDD VDD pmos_6p0 W=1.280000U L=0.500000U
M_i_6_1 VDD A3 ZN VDD pmos_6p0 W=1.280000U L=0.500000U
M_i_7_1 ZN A4 VDD VDD pmos_6p0 W=1.280000U L=0.500000U
.ENDS
