.SUBCKT gf180mcu_fd_sc_mcu9t5v0__dffrnq_4 D RN CLK Q VDD VSS
*.PININFO D:I RN:I CLK:I Q:O VDD:P VDD:P VSS:P VSS:G
M_tn10 ncki CLK VSS VSS nmos_6p0 W=0.790000U L=0.600000U
M_tn13 cki ncki VSS VSS nmos_6p0 W=0.790000U L=0.600000U
M_tn11 net10 D VSS VSS nmos_6p0 W=0.590000U L=0.600000U
M_tn15 net10 ncki net1 VSS nmos_6p0 W=0.590000U L=0.600000U
M_tn14 net1 cki net15 VSS nmos_6p0 W=0.590000U L=0.600000U
M_tn8 net12 net2 net15 VSS nmos_6p0 W=0.590000U L=0.600000U
M_tn9 VSS RN net12 VSS nmos_6p0 W=0.590000U L=0.600000U
M_tn18 VSS net1 net2 VSS nmos_6p0 W=0.590000U L=0.600000U
M_tn0 net8 cki net2 VSS nmos_6p0 W=0.590000U L=0.600000U
M_tn1 net11 ncki net8 VSS nmos_6p0 W=0.590000U L=0.600000U
M_tn12 net11 net4 VSS VSS nmos_6p0 W=0.590000U L=0.600000U
M_tn5 net0 RN VSS VSS nmos_6p0 W=0.590000U L=0.600000U
M_tn4 net4 net8 net0 VSS nmos_6p0 W=1.320000U L=0.600000U
M_tn3_15 Q net4 VSS VSS nmos_6p0 W=1.320000U L=0.600000U
M_tn3 Q net4 VSS VSS nmos_6p0 W=1.320000U L=0.600000U
M_tn3_15_13 Q net4 VSS VSS nmos_6p0 W=1.320000U L=0.600000U
M_tn3_10 Q net4 VSS VSS nmos_6p0 W=1.320000U L=0.600000U
M_tp8 ncki CLK VDD VDD pmos_6p0 W=1.380000U L=0.500000U
M_tp11 cki ncki VDD VDD pmos_6p0 W=1.380000U L=0.500000U
M_tp9 VDD D net10 VDD pmos_6p0 W=1.000000U L=0.500000U
M_tp15 net1 cki net10 VDD pmos_6p0 W=1.000000U L=0.500000U
M_tp7 net9 ncki net1 VDD pmos_6p0 W=1.000000U L=0.500000U
M_tp6 VDD net2 net9 VDD pmos_6p0 W=1.000000U L=0.500000U
M_tp12 net9 RN VDD VDD pmos_6p0 W=1.000000U L=0.500000U
M_tp18 VDD net1 net2 VDD pmos_6p0 W=1.000000U L=0.500000U
M_tp2 net2 ncki net8 VDD pmos_6p0 W=1.000000U L=0.500000U
M_tp3 net8 cki net11 VDD pmos_6p0 W=1.000000U L=0.500000U
M_tp10 net11 net4 VDD VDD pmos_6p0 W=1.000000U L=0.500000U
M_tp5 net4 RN VDD VDD pmos_6p0 W=1.830000U L=0.500000U
M_tp4 VDD net8 net4 VDD pmos_6p0 W=1.830000U L=0.500000U
M_tp1_13 Q net4 VDD VDD pmos_6p0 W=1.830000U L=0.500000U
M_tp1 Q net4 VDD VDD pmos_6p0 W=1.830000U L=0.500000U
M_tp1_13_25 Q net4 VDD VDD pmos_6p0 W=1.830000U L=0.500000U
M_tp1_30 Q net4 VDD VDD pmos_6p0 W=1.830000U L=0.500000U
.ENDS
