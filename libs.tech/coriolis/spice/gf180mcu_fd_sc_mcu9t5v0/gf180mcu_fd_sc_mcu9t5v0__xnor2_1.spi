.SUBCKT gf180mcu_fd_sc_mcu9t5v0__xnor2_1 A1 A2 ZN VDD VSS
*.PININFO A1:I A2:I ZN:O VDD:P VDD:P VSS:P VSS:G
*.EQN ZN=!(!((A1 * A2) + !(A1 + A2)))
M_i_6 net_2 A2 I VSS nmos_6p0 W=0.660000U L=0.600000U
M_i_7 VSS A1 net_2 VSS nmos_6p0 W=0.660000U L=0.600000U
M_i_2 net_0 I VSS VSS nmos_6p0 W=1.320000U L=0.600000U
M_i_0 ZN A1 net_0 VSS nmos_6p0 W=1.320000U L=0.600000U
M_i_1 net_0 A2 ZN VSS nmos_6p0 W=1.320000U L=0.600000U
M_i_8 I A2 VDD VDD pmos_6p0 W=0.915000U L=0.500000U
M_i_9 VDD A1 I VDD pmos_6p0 W=0.915000U L=0.500000U
M_i_5 ZN I VDD VDD pmos_6p0 W=1.830000U L=0.500000U
M_i_3 net_1 A1 ZN VDD pmos_6p0 W=1.830000U L=0.500000U
M_i_4 VDD A2 net_1 VDD pmos_6p0 W=1.830000U L=0.500000U
.ENDS
