.SUBCKT gf180mcu_fd_sc_mcu9t5v0__addh_2 A B CO S VDD VSS
*.PININFO A:I B:I CO:O S:O VDD:P VDD:P VSS:P VSS:G
*.EQN CO=(A * B);S=!((A * B) + !(A + B))
M_i_2_1 CO NCO VSS VSS nmos_6p0 W=1.320000U L=0.600000U
M_i_2_0 VSS NCO CO VSS nmos_6p0 W=1.320000U L=0.600000U
M_i_5 net_0 A VSS VSS nmos_6p0 W=1.320000U L=0.600000U
M_i_4 NCO B net_0 VSS nmos_6p0 W=1.320000U L=0.600000U
M_i_9 NS B net_1 VSS nmos_6p0 W=1.320000U L=0.600000U
M_i_8 net_1 A NS VSS nmos_6p0 W=1.320000U L=0.600000U
M_i_10 VSS NCO net_1 VSS nmos_6p0 W=1.320000U L=0.600000U
M_i_0_1 S NS VSS VSS nmos_6p0 W=1.320000U L=0.600000U
M_i_0_0 VSS NS S VSS nmos_6p0 W=1.320000U L=0.600000U
M_i_3_1 CO NCO VDD VDD pmos_6p0 W=1.830000U L=0.500000U
M_i_3_0 VDD NCO CO VDD pmos_6p0 W=1.830000U L=0.500000U
M_i_7 NCO A VDD VDD pmos_6p0 W=1.830000U L=0.500000U
M_i_6 VDD B NCO VDD pmos_6p0 W=1.830000U L=0.500000U
M_i_12 net_2 B VDD VDD pmos_6p0 W=1.830000U L=0.500000U
M_i_11 NS A net_2 VDD pmos_6p0 W=1.830000U L=0.500000U
M_i_13 VDD NCO NS VDD pmos_6p0 W=1.830000U L=0.500000U
M_i_1_1 S NS VDD VDD pmos_6p0 W=1.830000U L=0.500000U
M_i_1_0 VDD NS S VDD pmos_6p0 W=1.830000U L=0.500000U
.ENDS
