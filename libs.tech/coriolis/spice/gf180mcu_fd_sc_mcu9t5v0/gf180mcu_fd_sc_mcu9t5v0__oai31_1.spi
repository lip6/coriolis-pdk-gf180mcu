.SUBCKT gf180mcu_fd_sc_mcu9t5v0__oai31_1 A1 A2 A3 B ZN VDD VSS
*.PININFO A1:I A2:I A3:I B:I ZN:O VDD:P VDD:P VSS:P VSS:G
*.EQN ZN=!(((A1 + A2) + A3) * B)
M_i_3 net_0 B VSS VSS nmos_6p0 W=1.320000U L=0.600000U
M_i_0 ZN A1 net_0 VSS nmos_6p0 W=1.320000U L=0.600000U
M_i_1 net_0 A2 ZN VSS nmos_6p0 W=1.320000U L=0.600000U
M_i_2 ZN A3 net_0 VSS nmos_6p0 W=1.320000U L=0.600000U
M_i_7 ZN B VDD VDD pmos_6p0 W=1.645000U L=0.500000U
M_i_4 net_1 A1 ZN VDD pmos_6p0 W=1.830000U L=0.500000U
M_i_5 net_2 A2 net_1 VDD pmos_6p0 W=1.830000U L=0.500000U
M_i_6 VDD A3 net_2 VDD pmos_6p0 W=1.830000U L=0.500000U
.ENDS
