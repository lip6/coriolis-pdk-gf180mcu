.SUBCKT gf180mcu_fd_sc_mcu9t5v0__dffnq_4 D CLKN Q VDD VSS
*.PININFO D:I CLKN:I Q:O VDD:P VDD:P VSS:P VSS:G
M_tn9 ncki CLKN VSS VSS nmos_6p0 W=0.790000U L=0.600000U
M_tn16 cki ncki VSS VSS nmos_6p0 W=0.790000U L=0.600000U
M_tn10 VSS D net2 VSS nmos_6p0 W=0.590000U L=0.600000U
M_tn11 net2 cki net5 VSS nmos_6p0 W=0.590000U L=0.600000U
M_tn0 net5 ncki net11 VSS nmos_6p0 W=0.590000U L=0.600000U
M_tn1 VSS net10 net11 VSS nmos_6p0 W=0.590000U L=0.600000U
M_tn15 net10 net5 VSS VSS nmos_6p0 W=0.590000U L=0.600000U
M_tn2 net0 ncki net10 VSS nmos_6p0 W=0.590000U L=0.600000U
M_tn3 net7 cki net0 VSS nmos_6p0 W=0.590000U L=0.600000U
M_tn4 VSS net1 net7 VSS nmos_6p0 W=1.320000U L=0.600000U
M_tn5 net1 net0 VSS VSS nmos_6p0 W=1.320000U L=0.600000U
M_tn6_7 Q net1 VSS VSS nmos_6p0 W=1.320000U L=0.600000U
M_tn6 Q net1 VSS VSS nmos_6p0 W=1.320000U L=0.600000U
M_tn6_7_61 Q net1 VSS VSS nmos_6p0 W=1.320000U L=0.600000U
M_tn6_49 Q net1 VSS VSS nmos_6p0 W=1.320000U L=0.600000U
M_tp9 ncki CLKN VDD VDD pmos_6p0 W=1.380000U L=0.500000U
M_tp16 cki ncki VDD VDD pmos_6p0 W=1.380000U L=0.500000U
M_tp10 VDD D net2 VDD pmos_6p0 W=1.000000U L=0.500000U
M_tp11 net5 ncki net2 VDD pmos_6p0 W=1.000000U L=0.500000U
M_tp0 net4 cki net5 VDD pmos_6p0 W=1.000000U L=0.500000U
M_tp1 VDD net10 net4 VDD pmos_6p0 W=1.000000U L=0.500000U
M_tp15 net10 net5 VDD VDD pmos_6p0 W=1.000000U L=0.500000U
M_tp7 net0 cki net10 VDD pmos_6p0 W=1.000000U L=0.500000U
M_tp6 net7 ncki net0 VDD pmos_6p0 W=1.000000U L=0.500000U
M_tp2 VDD net1 net7 VDD pmos_6p0 W=1.830000U L=0.500000U
M_tp3 net1 net0 VDD VDD pmos_6p0 W=1.830000U L=0.500000U
M_tp4_13 Q net1 VDD VDD pmos_6p0 W=1.830000U L=0.500000U
M_tp4 Q net1 VDD VDD pmos_6p0 W=1.830000U L=0.500000U
M_tp4_13_64 Q net1 VDD VDD pmos_6p0 W=1.830000U L=0.500000U
M_tp4_55 Q net1 VDD VDD pmos_6p0 W=1.830000U L=0.500000U
.ENDS
