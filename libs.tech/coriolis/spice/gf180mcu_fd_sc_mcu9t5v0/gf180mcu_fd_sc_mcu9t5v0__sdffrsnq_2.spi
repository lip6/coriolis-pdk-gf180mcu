.SUBCKT gf180mcu_fd_sc_mcu9t5v0__sdffrsnq_2 D RN SE SETN SI CLK Q VDD VSS
*.PININFO D:I RN:I SE:I SETN:I SI:I CLK:I Q:O VDD:P VDD:P VSS:P VSS:G
M_tn12 net9 SE VSS VSS nmos_6p0 W=0.590000U L=0.600000U
M_tn9 VSS SI net17 VSS nmos_6p0 W=0.590000U L=0.600000U
M_tn10 net17 SE net14 VSS nmos_6p0 W=0.590000U L=0.600000U
M_tn0 net14 D net8 VSS nmos_6p0 W=0.590000U L=0.600000U
M_tn11 net8 net9 VSS VSS nmos_6p0 W=0.590000U L=0.600000U
M_tn1 ncki CLK VSS VSS nmos_6p0 W=0.790000U L=0.600000U
M_tn2 cki ncki VSS VSS nmos_6p0 W=0.790000U L=0.600000U
M_tn8 net14 ncki net3 VSS nmos_6p0 W=0.590000U L=0.600000U
M_tn5 net3 cki net16 VSS nmos_6p0 W=0.590000U L=0.600000U
M_tn6 net15 net4 net16 VSS nmos_6p0 W=0.590000U L=0.600000U
M_tn7 VSS RN net15 VSS nmos_6p0 W=0.590000U L=0.600000U
M_tn4 net0 net3 VSS VSS nmos_6p0 W=0.590000U L=0.600000U
M_tn3 net4 SETN net0 VSS nmos_6p0 W=0.590000U L=0.600000U
M_tn14 net5 cki net4 VSS nmos_6p0 W=0.590000U L=0.600000U
M_tn13 net7 ncki net5 VSS nmos_6p0 W=0.590000U L=0.600000U
M_tn15 net1 SETN net7 VSS nmos_6p0 W=0.590000U L=0.600000U
M_tn16 VSS net6 net1 VSS nmos_6p0 W=0.590000U L=0.600000U
M_tn18 net2 RN VSS VSS nmos_6p0 W=0.590000U L=0.600000U
M_tn17 net6 net5 net2 VSS nmos_6p0 W=1.320000U L=0.600000U
M_tn19 Q net6 VSS VSS nmos_6p0 W=1.320000U L=0.600000U
M_tn19_14 Q net6 VSS VSS nmos_6p0 W=1.320000U L=0.600000U
M_tp12 net9 SE VDD VDD pmos_6p0 W=1.000000U L=0.500000U
M_tp11 net12 SI VDD VDD pmos_6p0 W=1.000000U L=0.500000U
M_tp8 net10 net9 net12 VDD pmos_6p0 W=1.000000U L=0.500000U
M_tp0 net11 D net10 VDD pmos_6p0 W=1.000000U L=0.500000U
M_tp9 VDD SE net11 VDD pmos_6p0 W=1.000000U L=0.500000U
M_tp1 ncki CLK VDD VDD pmos_6p0 W=1.380000U L=0.500000U
M_tp2 cki ncki VDD VDD pmos_6p0 W=1.380000U L=0.500000U
M_tp10 net3 cki net10 VDD pmos_6p0 W=1.000000U L=0.500000U
M_tp7 net13 ncki net3 VDD pmos_6p0 W=1.000000U L=0.500000U
M_tp5 VDD net4 net13 VDD pmos_6p0 W=1.000000U L=0.500000U
M_tp6 net13 RN VDD VDD pmos_6p0 W=1.000000U L=0.500000U
M_tp4 VDD net3 net4 VDD pmos_6p0 W=1.000000U L=0.500000U
M_tp3 VDD SETN net4 VDD pmos_6p0 W=1.000000U L=0.500000U
M_tp20 net4 ncki net5 VDD pmos_6p0 W=1.000000U L=0.500000U
M_tp19 net5 cki net7 VDD pmos_6p0 W=1.000000U L=0.500000U
M_tp13 net7 SETN VDD VDD pmos_6p0 W=1.000000U L=0.500000U
M_tp14 net7 net6 VDD VDD pmos_6p0 W=1.000000U L=0.500000U
M_tp16 net6 RN VDD VDD pmos_6p0 W=1.830000U L=0.500000U
M_tp15 VDD net5 net6 VDD pmos_6p0 W=1.830000U L=0.500000U
M_tp17 Q net6 VDD VDD pmos_6p0 W=1.830000U L=0.500000U
M_tp17_7 Q net6 VDD VDD pmos_6p0 W=1.830000U L=0.500000U
.ENDS
